`include "pl_regs.vh" //automatically created and added by fwk with conf variables such a C_VERSION ...

/* default values of defined variables */
`ifndef C_ID
`define C_ID 0xE1C00100
`endif
`ifndef C_VERSION
`define C_VERSION 0x00000000
`endif
`ifndef C_PRJ_ID
`define C_PRJ_ID 0xE1C00010
`endif
`ifndef C_PRJ_VERSION
`define C_PRJ_VERSION 0x00000000
`endif
`ifndef C_PRJ_TIMESTAMP
`define C_PRJ_TIMESTAMP 0x00000000
`endif
`ifndef C_PRJ_SHASUM
`define C_PRJ_SHASUM 0x00000000
`endif

/*
  module a address space
*/
addrmap pl_regs {
  name = "Example module for the example application";
  desyrdl_interface = "AXI4L";


reg {
    desc="FPGA Version";
    default sw = rw;
    default hw = w;
    field {} val[32];
  } fpgaver @0x0;  


reg {
    desc="PS Leds";
    default sw = rw;
    default hw = r;
    field {} val[8];
  } leds @0x4;
  

reg {
    desc="Soft Trig";
    default sw = rw;
    default hw = r;  
    default swacc=true;
    default swmod=true;          
    field {} val[8];
  } softtrig @0x8; 
 
  
reg {
    desc="Soft Trig Buffer Ptr.  Buffer Point latched value gets put here on soft trigger";
    default sw = rw;
    default hw = w;
    field {} val[32];
  } softtrig_bufptr @0xC; 





/* PS1 10Hz Data */
reg {
    desc="PS1 DCCT 0";
    default sw = rw;
    default hw = w;
    field {} val[32];
  } ps1_dcct0 @0x20;  

reg {
    desc="PS1 DCCT 1";
    default sw = rw;
    default hw = w;
    field {} val[32];
  } ps1_dcct1 @0x24;  

reg {
    desc="PS1 DAC Setpoint Monitor";
    default sw = rw;
    default hw = w;
    field {} val[32];
  } ps1_dacsp @0x28;  

reg {
    desc="PS1 Voltage Monitor";
    default sw = rw;
    default hw = w;
    field {} val[32];
  } ps1_volt @0x2C;  

reg {
    desc="PS1 GND Monitor";
    default sw = rw;
    default hw = w;
    field {} val[32];
  } ps1_gnd @0x30; 

reg {
    desc="PS1 Spare Monitor";
    default sw = rw;
    default hw = w;
    field {} val[32];
  } ps1_spare @0x34; 

reg {
    desc="PS1 Regulator Output Monitor";
    default sw = rw;
    default hw = w;
    field {} val[32];
  } ps1_reg @0x38; 

reg {
    desc="PS1 Error";
    default sw = rw;
    default hw = w;
    field {} val[32];
  } ps1_err @0x3C; 



/* PS2 10 Hz Data  */
reg {
    desc="PS2 DCCT 0";
    default sw = rw;
    default hw = w;
    field {} val[32];
  } ps2_dcct0 @0x40;  

reg {
    desc="PS2 DCCT 1";
    default sw = rw;
    default hw = w;
    field {} val[32];
  } ps2_dcct1 @0x44;  

reg {
    desc="PS2 DAC Setpoint Monitor";
    default sw = rw;
    default hw = w;
    field {} val[32];
  } ps2_dacsp @0x48;  

reg {
    desc="PS2 Voltage Monitor";
    default sw = rw;
    default hw = w;
    field {} val[32];
  } ps2_volt @0x4C;  

reg {
    desc="PS2 GND Monitor";
    default sw = rw;
    default hw = w;
    field {} val[32];
  } ps2_gnd @0x50; 

reg {
    desc="PS2 Spare Monitor";
    default sw = rw;
    default hw = w;
    field {} val[32];
  } ps2_spare @0x54; 

reg {
    desc="PS2 Regulator Output Monitor";
    default sw = rw;
    default hw = w;
    field {} val[32];
  } ps2_reg @0x58; 

reg {
    desc="PS2 Error Monitor";
    default sw = rw;
    default hw = w;
    field {} val[32];
  } ps2_err @0x5C; 



/* PS3 10Hz Data */

reg {
    desc="PS3 DCCT 0";
    default sw = rw;
    default hw = w;
    field {} val[32];
  } ps3_dcct0 @0x60;  

reg {
    desc="PS3 DCCT 1";
    default sw = rw;
    default hw = w;
    field {} val[32];
  } ps3_dcct1 @0x64;  

reg {
    desc="PS3 DAC Setpoint Monitor";
    default sw = rw;
    default hw = w;
    field {} val[32];
  } ps3_dacsp @0x68;  

reg {
    desc="PS3 Voltage Monitor";
    default sw = rw;
    default hw = w;
    field {} val[32];
  } ps3_volt @0x6C;  

reg {
    desc="PS3 GND Monitor";
    default sw = rw;
    default hw = w;
    field {} val[32];
  } ps3_gnd @0x70; 

reg {
    desc="PS3 Spare Monitor";
    default sw = rw;
    default hw = w;
    field {} val[32];
  } ps3_spare @0x74; 

reg {
    desc="PS3 Regulator Output Monitor";
    default sw = rw;
    default hw = w;
    field {} val[32];
  } ps3_reg @0x78; 

reg {
    desc="PS3 Error Monitor";
    default sw = rw;
    default hw = w;
    field {} val[32];
  } ps3_err @0x7C; 



/*  PS4 10Hz Data  */

reg {
    desc="PS4 DCCT 0";
    default sw = rw;
    default hw = w;
    field {} val[32];
  } ps4_dcct0 @0x80;  

reg {
    desc="PS3 DCCT 1";
    default sw = rw;
    default hw = w;
    field {} val[32];
  } ps4_dcct1 @0x84;  

reg {
    desc="PS4 DAC Setpoint Monitor";
    default sw = rw;
    default hw = w;
    field {} val[32];
  } ps4_dacsp @0x88;  

reg {
    desc="PS4 Voltage Monitor";
    default sw = rw;
    default hw = w;
    field {} val[32];
  } ps4_volt @0x8C;  

reg {
    desc="PS4 GND Monitor";
    default sw = rw;
    default hw = w;
    field {} val[32];
  } ps4_gnd @0x90; 

reg {
    desc="PS4 Spare Monitor";
    default sw = rw;
    default hw = w;
    field {} val[32];
  } ps4_spare @0x94; 

reg {
    desc="PS4 Regulator Output";
    default sw = rw;
    default hw = w;
    field {} val[32];
  } ps4_reg @0x98; 

reg {
    desc="PS4 Error Monitor";
    default sw = rw;
    default hw = w;
    field {} val[32];
  } ps4_err @0x9C; 



/* PS1 DAC */

reg {
    desc="PS1 DAC Offset";
    default sw = rw;
    default hw = r;
    field {} val[16];
  } ps1_dac_offset @0x100;

reg {
    desc="PS1 DAC Gain";
    default sw = rw;
    default hw = r;
    field {} val[16];
  } ps1_dac_gain @0x104;

reg {
    desc="PS1 DAC SetPoint - when in jumpmode";
    default sw = rw;
    default hw = r;
    field {} val[20];
  } ps1_dac_setpt @0x108;
  
reg {
    desc="PS1 DAC JumpMode";
    default sw = rw;
    default hw = r;
    default swacc=true;
    default swmod=true;    
    field {} val[1];
  } ps1_dac_jumpmode @0x10C;  
  

reg {
    desc="PS1 DAC Control bit0=op_gnd, bit1=sdo_dis, bit2=dac_tri, bit3=rbuf, bit4=bin2sc";
    default sw = rw;
    default hw = r;   
    field {} val[8];
  } ps1_dac_cntrl @0x110;

reg {
    desc="PS1 DAC Reset";
    default sw = rw;
    default hw = r;    
    field {} val[1];
  } ps1_dac_reset @0x114;


reg {
    desc="PS1 DAC Ramp Table Length";
    default sw = rw;
    default hw = r;
    field {} val[16];
  } ps1_dac_ramplen @0x118; 


reg {
    desc="PS1 DAC Ramp Table Address";
    default sw = rw;
    default hw = r;
    field {} val[16];
  } ps1_dac_rampaddr @0x11C; 

reg {
    desc="PS1 DAC Ramp Table Data";
    default sw = rw;
    default hw = r;
    default swacc=true;
    default swmod=true;   
    field {} val[20];
  } ps1_dac_rampdata @0x120; 

reg {
    desc="PS1 DAC Run RampTable";
    default sw = rw;
    default hw = r;
    default swacc=true;
    default swmod=true;    
    field {} val[1];
  } ps1_dac_runramp @0x124;
  
  reg {
    desc="PS1 DAC Ramptable Run Active";
    default sw = rw;
    default hw = w;
    field {} val[1];
  } ps1_dac_rampactive @0x128;

  reg {
    desc="PS1 DAC Ramptable Run Current Address";
    default sw = rw;
    default hw = w;
    field {} val[16];
  } ps1_dac_currampaddr @0x12C;








/* Digital I/O */

reg {
    desc="PS1 Digital Outputs bit0=On1, bit1=On2, bit2=Reset, bit3=spare, bit4=Park";
    default sw = rw;
    default hw = r; 
    field {} val[5];
  } ps1_digout @0x200; 
  
reg {
    desc="PS1 Digital Inputs bit0=Acon, bit1=Flt1, bit2=Flt2, bit3=spare";
    default sw = rw;
    default hw = w; 
    field {} val[4];
  } ps1_digin @0x204;   
  
 reg {
    desc="PS2 Digital Outputs bit0=On1, bit1=On2, bit2=Reset, bit3=spare, bit4=Park";
    default sw = rw;
    default hw = r; 
    field {} val[5];
  } ps2_digout @0x208; 
  
reg {
    desc="PS2 Digital Inputs bit0=Acon, bit1=Flt1, bit2=Flt2, bit3=spare";
    default sw = rw;
    default hw = w; 
    field {} val[4];
  } ps2_digin @0x20C;  


reg {
    desc="PS3 Digital Outputs bit0=On1, bit1=On2, bit2=Reset, bit3=spare, bit4=Park";
    default sw = rw;
    default hw = r; 
    field {} val[5];
  } ps3_digout @0x210; 
  
reg {
    desc="PS3 Digital Inputs bit0=Acon, bit1=Flt1, bit2=Flt2, bit3=spare";
    default sw = rw;
    default hw = w; 
    field {} val[4];
  } ps3_digin @0x214;   
  
 reg {
    desc="PS4 Digital Outputs bit0=On1, bit1=On2, bit2=Reset, bit3=spare, bit4=Park";
    default sw = rw;
    default hw = r; 
    field {} val[5];
  } ps4_digout @0x218; 
  
reg {
    desc="PS4 Digital Inputs bit0=Acon, bit1=Flt1, bit2=Flt2, bit3=spare";
    default sw = rw;
    default hw = w; 
    field {} val[4];
  } ps4_digin @0x21C;  



/* SnapShot Buffer Stats */
  reg {
    desc="Snapshot 20 sec circular buffer current address pointer";
    default sw = rw;
    default hw = w;
    field {} val[32];
  } snapshot_addrptr @0x300;


  reg {
    desc="Snapshot 20 sec circular buffer total data points written";
    default sw = rw;
    default hw = w;
    field {} val[32];
  } snapshot_totaltrigs @0x304;





/* DESY Version registers */

  reg {
    desc = "Module Identification Number";
    default sw = r;
    default hw = r;
    field {} data[32] = `C_ID;
  } ID @0x400;

  reg {
    desc = "Module Version Number";
    default sw = r;
    default hw = r;
    field {} changes [8] =  `C_VERSION & 0x000000FF;
    field {} patch [8]   = (`C_VERSION & 0x0000FF00) >> 8;
    field {} minor [8]   = (`C_VERSION & 0x00FF0000) >> 16;
    field {} major [8]   = (`C_VERSION & 0xFF000000) >> 24;
  } VERSION @0x404;

  reg {
    desc="Project Identification Number";
    default sw = r;
    default hw = r;
    field {} data[32] = `C_PRJ_ID;
  } PRJ_ID @0x408;

  reg {
    desc="Project Version Number";
    default sw = r;
    default hw = r;
    field {} changes [8] =  `C_PRJ_VERSION & 0x000000FF;
    field {} patch [8]   = (`C_PRJ_VERSION & 0x0000FF00) >> 8;
    field {} minor [8]   = (`C_PRJ_VERSION & 0x00FF0000) >> 16;
    field {} major [8]   = (`C_PRJ_VERSION & 0xFF000000) >> 24;
  } PRJ_VERSION @0x40C;

  reg {
    desc="Project Repository check sum.";
    default sw = r;
    default hw = r;
      field {} data[32] = `C_PRJ_SHASUM;
  } PRJ_SHASUM @0x410;

  reg {
    desc="Project compilation timestamp";
    default sw = r;
    default hw = r;
    field {} data[32] = `C_PRJ_TIMESTAMP;
  } PRJ_TIMESTAMP @0x414;







};
