`include "pl_regs.vh" //automatically created and added by fwk with conf variables such a C_VERSION ...

/* default values of defined variables */
`ifndef C_ID
`define C_ID 0xE1C00100
`endif
`ifndef C_VERSION
`define C_VERSION 0x00000000
`endif
`ifndef C_PRJ_ID
`define C_PRJ_ID 0xE1C00010
`endif
`ifndef C_PRJ_VERSION
`define C_PRJ_VERSION 0x00000000
`endif
`ifndef C_PRJ_TIMESTAMP
`define C_PRJ_TIMESTAMP 0x00000000
`endif
`ifndef C_PRJ_SHASUM
`define C_PRJ_SHASUM 0x00000000
`endif

/*
  module a address space
*/
addrmap pl_regs {
  name = "Example module for the example application";
  desyrdl_interface = "AXI4L";


reg {
    desc="FPGA Version";
    default sw = rw;
    default hw = w;
    field {} data[32];
  } fpgaver @0x0;  


  reg {
    desc="PS Leds";
    default sw = rw;
    default hw = r;
    field {} data[8];
  } leds @0x4;



/* PS1 10Hz Data */
reg {
    desc="PS1 DCCT 0";
    default sw = rw;
    default hw = w;
    field {} val[32];
  } ps1_dcct0 @0x20;  

reg {
    desc="PS1 DCCT1";
    default sw = rw;
    default hw = w;
    field {} val[32];
  } ps1_dcct1 @0x24;  

reg {
    desc="PS1 DAC Setpoint";
    default sw = rw;
    default hw = w;
    field {} val[32];
  } ps1_dacsp @0x28;  

reg {
    desc="PS1 Voltage Monitor";
    default sw = rw;
    default hw = w;
    field {} val[32];
  } ps1_volt @0x2C;  

reg {
    desc="PS1 GND Monitor";
    default sw = rw;
    default hw = w;
    field {} val[32];
  } ps1_gnd @0x30; 

reg {
    desc="PS1 Spare Monitor";
    default sw = rw;
    default hw = w;
    field {} val[32];
  } ps1_spare @0x34; 

reg {
    desc="PS1 Regulator Output";
    default sw = rw;
    default hw = w;
    field {} val[32];
  } ps1_reg @0x38; 

reg {
    desc="PS1 Error";
    default sw = rw;
    default hw = w;
    field {} val[32];
  } ps1_err @0x3C; 



/* PS2 10 Hz Data  */
reg {
    desc="PS2 DCCT 0";
    default sw = rw;
    default hw = w;
    field {} val[32];
  } ps2_dcct0 @0x40;  

reg {
    desc="PS2 DCCT1";
    default sw = rw;
    default hw = w;
    field {} val[32];
  } ps2_dcct1 @0x44;  

reg {
    desc="PS2 DAC Setpoint";
    default sw = rw;
    default hw = w;
    field {} val[32];
  } ps2_dacsp @0x48;  

reg {
    desc="PS2 Voltage Monitor";
    default sw = rw;
    default hw = w;
    field {} val[32];
  } ps2_volt @0x4C;  

reg {
    desc="PS2 GND Monitor";
    default sw = rw;
    default hw = w;
    field {} val[32];
  } ps2_gnd @0x50; 

reg {
    desc="PS2 Spare Monitor";
    default sw = rw;
    default hw = w;
    field {} val[32];
  } ps2_spare @0x54; 

reg {
    desc="PS2 Regulator Output";
    default sw = rw;
    default hw = w;
    field {} val[32];
  } ps2_reg @0x58; 

reg {
    desc="PS2 Error";
    default sw = rw;
    default hw = w;
    field {} val[32];
  } ps2_err @0x5C; 



/* PS3 10Hz Data */

reg {
    desc="PS3 DCCT 0";
    default sw = rw;
    default hw = w;
    field {} val[32];
  } ps3_dcct0 @0x60;  

reg {
    desc="PS3 DCCT1";
    default sw = rw;
    default hw = w;
    field {} val[32];
  } ps3_dcct1 @0x64;  

reg {
    desc="PS3 DAC Setpoint";
    default sw = rw;
    default hw = w;
    field {} val[32];
  } ps3_dacsp @0x68;  

reg {
    desc="PS3 Voltage Monitor";
    default sw = rw;
    default hw = w;
    field {} val[32];
  } ps3_volt @0x6C;  

reg {
    desc="PS3 GND Monitor";
    default sw = rw;
    default hw = w;
    field {} val[32];
  } ps3_gnd @0x70; 

reg {
    desc="PS3 Spare Monitor";
    default sw = rw;
    default hw = w;
    field {} val[32];
  } ps3_spare @0x74; 

reg {
    desc="PS3 Regulator Output";
    default sw = rw;
    default hw = w;
    field {} val[32];
  } ps3_reg @0x78; 

reg {
    desc="PS3 Error";
    default sw = rw;
    default hw = w;
    field {} val[32];
  } ps3_err @0x7C; 



/*  PS4 10Hz Data  */

reg {
    desc="PS4 DCCT 0";
    default sw = rw;
    default hw = w;
    field {} val[32];
  } ps4_dcct0 @0x80;  

reg {
    desc="PS3 DCCT1";
    default sw = rw;
    default hw = w;
    field {} val[32];
  } ps4_dcct1 @0x84;  

reg {
    desc="PS4 DAC Setpoint";
    default sw = rw;
    default hw = w;
    field {} val[32];
  } ps4_dacsp @0x88;  

reg {
    desc="PS4 Voltage Monitor";
    default sw = rw;
    default hw = w;
    field {} val[32];
  } ps4_volt @0x8C;  

reg {
    desc="PS4 GND Monitor";
    default sw = rw;
    default hw = w;
    field {} val[32];
  } ps4_gnd @0x90; 

reg {
    desc="PS4 Spare Monitor";
    default sw = rw;
    default hw = w;
    field {} val[32];
  } ps4_spare @0x94; 

reg {
    desc="PS4 Regulator Output";
    default sw = rw;
    default hw = w;
    field {} val[32];
  } ps4_reg @0x98; 

reg {
    desc="PS4 Error";
    default sw = rw;
    default hw = w;
    field {} val[32];
  } ps4_err @0x9C; 









  reg {
    desc = "Module Identification Number";
    default sw = r;
    default hw = r;
    field {} data[32] = `C_ID;
  } ID @0x400;

  reg {
    desc = "Module Version Number";
    default sw = r;
    default hw = r;
    field {} changes [8] =  `C_VERSION & 0x000000FF;
    field {} patch [8]   = (`C_VERSION & 0x0000FF00) >> 8;
    field {} minor [8]   = (`C_VERSION & 0x00FF0000) >> 16;
    field {} major [8]   = (`C_VERSION & 0xFF000000) >> 24;
  } VERSION @0x404;

  reg {
    desc="Project Identification Number";
    default sw = r;
    default hw = r;
    field {} data[32] = `C_PRJ_ID;
  } PRJ_ID @0x408;

  reg {
    desc="Project Version Number";
    default sw = r;
    default hw = r;
    field {} changes [8] =  `C_PRJ_VERSION & 0x000000FF;
    field {} patch [8]   = (`C_PRJ_VERSION & 0x0000FF00) >> 8;
    field {} minor [8]   = (`C_PRJ_VERSION & 0x00FF0000) >> 16;
    field {} major [8]   = (`C_PRJ_VERSION & 0xFF000000) >> 24;
  } PRJ_VERSION @0x40C;

  reg {
    desc="Project Repository check sum.";
    default sw = r;
    default hw = r;
      field {} data[32] = `C_PRJ_SHASUM;
  } PRJ_SHASUM @0x410;

  reg {
    desc="Project compilation timestamp";
    default sw = r;
    default hw = r;
    field {} data[32] = `C_PRJ_TIMESTAMP;
  } PRJ_TIMESTAMP @0x414;







};
