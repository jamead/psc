`include "pl_regs.vh" //automatically created and added by fwk with conf variables such a C_VERSION ...

/* default values of defined variables */
`ifndef C_ID
`define C_ID 0xE1C00100
`endif
`ifndef C_VERSION
`define C_VERSION 0x00000000
`endif
`ifndef C_PRJ_ID
`define C_PRJ_ID 0xE1C00010
`endif
`ifndef C_PRJ_VERSION
`define C_PRJ_VERSION 0x00000000
`endif
`ifndef C_PRJ_TIMESTAMP
`define C_PRJ_TIMESTAMP 0x00000000
`endif
`ifndef C_PRJ_SHASUM
`define C_PRJ_SHASUM 0x00000000
`endif

/*
  module a address space
*/
addrmap pl_regs {
  name = "Example module for the example application";
  desyrdl_interface = "AXI4L";


reg {
    desc="FPGA Version";
    default sw = rw;
    default hw = w;
    field {} val[32];
  } fpgaver @0x0;  


reg {
    desc="PS Leds";
    default sw = rw;
    default hw = r;
    field {} val[8];
  } leds @0x4;
  

reg {
    desc="EVR Timestamp (s)";
    default sw = rw;
    default hw = w;
    field {} val[32];
  } evr_ts_s @0x10; 

reg {
    desc="EVR Timestamp (ns)";
    default sw = rw;
    default hw = w;
    field {} val[32];
  } evr_ts_ns @0x14; 
  
reg {
    desc="EVR Reset";
    default sw = rw;
    default hw = r;
    field {} val[8];
  } evr_reset @0x18;


reg {
    desc="EVR Injection Event Code";
    default sw = rw;
    default hw = r;
    field {} val[8];
  } evr_inj_eventno @0x20;

reg {
    desc="EVR Post Mortem Event Code";
    default sw = rw;
    default hw = r;
    field {} val[8];
  } evr_pm_eventno @0x24;






/**** Channel 1 ****/

/* 10Hz Data */
reg {
    desc="PS1 DCCT 0";
    default sw = rw;
    default hw = w;
    field {} val[32];
  } ps1_dcct0 @0x100;  

reg {
    desc="PS1 DCCT 1";
    default sw = rw;
    default hw = w;
    field {} val[32];
  } ps1_dcct1 @0x104;  

reg {
    desc="PS1 DAC Monitor";
    default sw = rw;
    default hw = w;
    field {} val[32];
  } ps1_dacmon @0x108;  

reg {
    desc="PS1 Voltage Monitor";
    default sw = rw;
    default hw = w;
    field {} val[32];
  } ps1_volt @0x10C;  

reg {
    desc="PS1 GND Monitor";
    default sw = rw;
    default hw = w;
    field {} val[32];
  } ps1_gnd @0x110; 

reg {
    desc="PS1 Spare Monitor";
    default sw = rw;
    default hw = w;
    field {} val[32];
  } ps1_spare @0x114; 

reg {
    desc="PS1 Regulator Output Monitor";
    default sw = rw;
    default hw = w;
    field {} val[32];
  } ps1_reg @0x118; 

reg {
    desc="PS1 Error Monitor";
    default sw = rw;
    default hw = w;
    field {} val[32];
  } ps1_err @0x11C; 



/* DAC */

reg {
    desc="PS1 DAC Offset";
    default sw = rw;
    default hw = r;
    field {} val[32];
  } ps1_dac_setpt_offset @0x120;

reg {
    desc="PS1 DAC Gain";
    default sw = rw;
    default hw = r;
    field {} val[32];
  } ps1_dac_setpt_gain @0x124;

reg {
    desc="PS1 DAC SetPoint - when in jumpmode";
    default sw = rw;
    default hw = r;
    field {} val[20];
  } ps1_dac_setpt @0x128;
  
reg {
    desc="PS1 DAC Mode 0=smooth ramp, 1=ramp table, 2=FOFB, 3=Jump Mode";
    default sw = rw;
    default hw = r;
    default swacc=true;
    default swmod=true;    
    field {} val[2];
  } ps1_dac_opmode @0x12C;  
  

reg {
    desc="PS1 DAC Control bit0=op_gnd, bit1=sdo_dis, bit2=dac_tri, bit3=rbuf, bit4=bin2sc";
    default sw = rw;
    default hw = r;   
    field {} val[8];
  } ps1_dac_cntrl @0x130;

reg {
    desc="PS1 DAC Reset";
    default sw = rw;
    default hw = r;    
    field {} val[1];
  } ps1_dac_reset @0x134;


reg {
    desc="PS1 DAC Ramp Table Length";
    default sw = rw;
    default hw = r;
    field {} val[16];
  } ps1_dac_ramplen @0x138; 


reg {
    desc="PS1 DAC Ramp Table Address";
    default sw = rw;
    default hw = r;
    field {} val[16];
  } ps1_dac_rampaddr @0x13C; 

reg {
    desc="PS1 DAC Ramp Table Data";
    default sw = rw;
    default hw = r;
    default swacc=true;
    default swmod=true;   
    field {} val[20];
  } ps1_dac_rampdata @0x140; 

reg {
    desc="PS1 DAC Run RampTable";
    default sw = rw;
    default hw = r;
    default swacc=true;
    default swmod=true;    
    field {} val[1];
  } ps1_dac_runramp @0x144;
  
reg {
    desc="PS1 DAC Ramptable Run Active";
    default sw = rw;
    default hw = w;
    field {} val[1];
  } ps1_dac_rampactive @0x148;

  reg {
    desc="PS1 DAC Current SetPt ";
    default sw = rw;
    default hw = w;
    field {} val[32];
  } ps1_dac_currsetpt @0x14C;


/* Gain and Offset */
reg {
    desc="PS1 DCCT 0 Offset";
    default sw = rw;
    default hw = r;
    field {} val[32];
  } ps1_dcct0_offset @0x150;

reg {
    desc="PS1 DCCT 0 Gain";
    default sw = rw;
    default hw = r;
    field {} val[32];
  } ps1_dcct0_gain @0x154;

reg {
    desc="PS1 DCCT 1 Offset";
    default sw = rw;
    default hw = r;
    field {} val[32];
  } ps1_dcct1_offset @0x158;

reg {
    desc="PS1 DCCT 1 Gain";
    default sw = rw;
    default hw = r;
    field {} val[32];
  } ps1_dcct1_gain @0x15C;


reg {
    desc="PS1 DAC Monitor Offset";
    default sw = rw;
    default hw = r;
    field {} val[32];
  } ps1_dacmon_offset @0x160;

reg {
    desc="PS1 DAC Monitor Gain";
    default sw = rw;
    default hw = r;
    field {} val[32];
  } ps1_dacmon_gain @0x164;

reg {
    desc="PS1 Voltage Monitor Offset";
    default sw = rw;
    default hw = r;
    field {} val[32];
  } ps1_volt_offset @0x168;

reg {
    desc="PS1 Voltage Monitor Gain";
    default sw = rw;
    default hw = r;
    field {} val[32];
  } ps1_volt_gain @0x16C;

reg {
    desc="PS1 GND Monitor Offset";
    default sw = rw;
    default hw = r;
    field {} val[32];
  } ps1_gnd_offset @0x170;

reg {
    desc="PS1 GND Monitor Gain";
    default sw = rw;
    default hw = r;
    field {} val[32];
  } ps1_gnd_gain @0x174;
 
reg {
    desc="PS1 Spare Monitor Offset";
    default sw = rw;
    default hw = r;
    field {} val[32];
  } ps1_spare_offset @0x178;

reg {
    desc="PS1 Spare Monitor Gain";
    default sw = rw;
    default hw = r;
    field {} val[32];
  } ps1_spare_gain @0x17C;
 
reg {
    desc="PS1 Regulator Output Offset";
    default sw = rw;
    default hw = r;
    field {} val[32];
  } ps1_reg_offset @0x180;

reg {
    desc="PS1 Regulator Output Gain";
    default sw = rw;
    default hw = r;
    field {} val[32];
  } ps1_reg_gain @0x184;
 
reg {
    desc="PS1 Error Monitor Offset";
    default sw = rw;
    default hw = r;
    field {} val[32];
  } ps1_err_offset @0x188;

reg {
    desc="PS1 Error Monitor Gain";
    default sw = rw;
    default hw = r;
    field {} val[32];
  } ps1_err_gain @0x18C;
 
reg {
    desc="PS1 DCCT1 Over Current Fault Threshold";
    default sw = rw;
    default hw = r;
    field {} val[20];
  } ps1_ovc1_thresh @0x190;
 
reg {
    desc="PS1 DCCT2 Over Current Fault Threshold";
    default sw = rw;
    default hw = r;
    field {} val[20];
  } ps1_ovc2_thresh @0x194;
 
reg {
    desc="PS1 Over Voltage Fault Threshold";
    default sw = rw;
    default hw = r;
    field {} val[16];
  } ps1_ovv_thresh @0x198;
 
reg {
    desc="PS1 PID Error1 Fault Threshold";
    default sw = rw;
    default hw = r;
    field {} val[16];
  } ps1_err1_thresh @0x19C;

reg {
    desc="PS1 PID Error2 Fault Threshold";
    default sw = rw;
    default hw = r;
    field {} val[16];
  } ps1_err2_thresh @0x1A0;

reg {
    desc="PS1 Gnd Current Fault Threshold";
    default sw = rw;
    default hw = r;
    field {} val[16];
  } ps1_ignd_thresh @0x1A4;

reg {
    desc="PS1 DCCT1 Over Current Fault Counter Limit";
    default sw = rw;
    default hw = r;
    field {} val[16];
  } ps1_ovc1_cntlim @0x1A8;
 

reg {
    desc="PS1 DCCT2 Over Current Fault Counter Limit";
    default sw = rw;
    default hw = r;
    field {} val[16];
  } ps1_ovc2_cntlim @0x1AC;
 

reg {
    desc="PS1 Over Voltage Fault Counter Limit";
    default sw = rw;
    default hw = r;
    field {} val[16];
  } ps1_ovv_cntlim @0x1B0;
 
reg {
    desc="PS1 PID Error1 Fault Counter Limit";
    default sw = rw;
    default hw = r;
    field {} val[16];
  } ps1_err1_cntlim @0x1B4;

reg {
    desc="PS1 PID Error2 Fault Counter Limit";
    default sw = rw;
    default hw = r;
    field {} val[16];
  } ps1_err2_cntlim @0x1B8;

reg {
    desc="PS1 Gnd Current Fault Counter Limit";
    default sw = rw;
    default hw = r;
    field {} val[16];
  } ps1_ignd_cntlim @0x1BC;

reg {
    desc="PS1 Digital DCCT Counter Limit";
    default sw = rw;
    default hw = r;
    field {} val[16];
  } ps1_dcct_cntlim @0x1C0;

reg {
    desc="PS1 Fault1 Counter Limit";
    default sw = rw;
    default hw = r;
    field {} val[16];
  } ps1_flt1_cntlim @0x1C4;

reg {
    desc="PS1 Fault2 Counter Limit";
    default sw = rw;
    default hw = r;
    field {} val[16];
  } ps1_flt2_cntlim @0x1C8;

reg {
    desc="PS1 Fault3 Counter Limit";
    default sw = rw;
    default hw = r;
    field {} val[16];
  } ps1_flt3_cntlim @0x1CC;

reg {
    desc="PS1 On Counter Limit";
    default sw = rw;
    default hw = r;
    field {} val[16];
  } ps1_on_cntlim @0x1D0;

reg {
    desc="PS1 Fault Clear";
    default sw = rw;
    default hw = r;
    field {} val[1];
  } ps1_fault_clear @0x1D4;

reg {
    desc="PS1 Fault Mask";
    default sw = rw;
    default hw = r;
    field {} val[16];
  } ps1_fault_mask @0x1D8;

reg {
    desc="PS1 HeartBeat Counter Limit";
    default sw = rw;
    default hw = r;
    field {} val[16];
  } ps1_heartbeat_cntlim @0x1DC;


reg {
    desc="PS1 Digital Outputs bit0=On1";
    default sw = rw;
    default hw = r; 
    field {} val[1];
  } ps1_digout_on1 @0x1E0; 
  
reg {
    desc="PS1 Digital Outputs bit1=On2";
    default sw = rw;
    default hw = r; 
    field {} val[1];
  } ps1_digout_on2 @0x1E4; 
  
reg {
    desc="PS1 Digital Outputs bit2=Reset";
    default sw = rw;
    default hw = r; 
    field {} val[1];
  } ps1_digout_reset @0x1E8; 
      
reg {
    desc="PS1 Digital Outputs bit3=spare";
    default sw = rw;
    default hw = r; 
    field {} val[1];
  } ps1_digout_spare @0x1EC; 
    
 reg {
    desc="PS1 Digital Outputs bit4=Park";
    default sw = rw;
    default hw = r; 
    field {} val[1];
  } ps1_digout_park @0x1F0; 
   
   
reg {
    desc="PS1 Digital Inputs bit0=Acon, bit1=Flt1, bit2=Flt2, bit3=spare, bit4=DCCTflt";
    default sw = rw;
    default hw = w; 
    field {} val[5];
  } ps1_digin @0x1F4; 


reg {
    desc="PS1 Active Faults (Live)";
    default sw = rw;
    default hw = w; 
    field {} val[16];
  } ps1_faults_live @0x1F8; 

reg {
    desc="PS1 Active Faults (Latched)";
    default sw = rw;
    default hw = w; 
    field {} val[16];
  } ps1_faults_lat @0x1FC; 






/**** Channel 2 *****/


/* PS2 10 Hz Data  */
reg {
    desc="PS2 DCCT 0";
    default sw = rw;
    default hw = w;
    field {} val[32];
  } ps2_dcct0 @0x200;  

reg {
    desc="PS2 DCCT 1";
    default sw = rw;
    default hw = w;
    field {} val[32];
  } ps2_dcct1 @0x204;  

reg {
    desc="PS2 DAC Monitor";
    default sw = rw;
    default hw = w;
    field {} val[32];
  } ps2_dacmon @0x208;  

reg {
    desc="PS2 Voltage Monitor";
    default sw = rw;
    default hw = w;
    field {} val[32];
  } ps2_volt @0x20C;  

reg {
    desc="PS2 GND Monitor";
    default sw = rw;
    default hw = w;
    field {} val[32];
  } ps2_gnd @0x210; 

reg {
    desc="PS2 Spare Monitor";
    default sw = rw;
    default hw = w;
    field {} val[32];
  } ps2_spare @0x214; 

reg {
    desc="PS2 Regulator Output Monitor";
    default sw = rw;
    default hw = w;
    field {} val[32];
  } ps2_reg @0x218; 

reg {
    desc="PS2 Error Monitor";
    default sw = rw;
    default hw = w;
    field {} val[32];
  } ps2_err @0x21C; 


/* DAC */
reg {
    desc="PS2 DAC Offset";
    default sw = rw;
    default hw = r;
    field {} val[32];
  } ps2_dac_setpt_offset @0x220;

reg {
    desc="PS2 DAC Gain";
    default sw = rw;
    default hw = r;
    field {} val[32];
  } ps2_dac_setpt_gain @0x224;

reg {
    desc="PS2 DAC SetPoint - when in jumpmode";
    default sw = rw;
    default hw = r;
    field {} val[20];
  } ps2_dac_setpt @0x228;
  
reg {
    desc="PS2 DAC Mode 0=smooth ramp, 1=ramp table, 2=FOFB, 3=Jump Mode";
    default sw = rw;
    default hw = r;
    default swacc=true;
    default swmod=true;    
    field {} val[2];
  } ps2_dac_opmode @0x22C;  
  

reg {
    desc="PS2 DAC Control bit0=op_gnd, bit1=sdo_dis, bit2=dac_tri, bit3=rbuf, bit4=bin2sc";
    default sw = rw;
    default hw = r;   
    field {} val[8];
  } ps2_dac_cntrl @0x230;

reg {
    desc="PS2 DAC Reset";
    default sw = rw;
    default hw = r;    
    field {} val[1];
  } ps2_dac_reset @0x234;


reg {
    desc="PS2 DAC Ramp Table Length";
    default sw = rw;
    default hw = r;
    field {} val[16];
  } ps2_dac_ramplen @0x238; 


reg {
    desc="PS2 DAC Ramp Table Address";
    default sw = rw;
    default hw = r;
    field {} val[16];
  } ps2_dac_rampaddr @0x23C; 

reg {
    desc="PS2 DAC Ramp Table Data";
    default sw = rw;
    default hw = r;
    default swacc=true;
    default swmod=true;   
    field {} val[20];
  } ps2_dac_rampdata @0x240; 

reg {
    desc="PS2 DAC Run RampTable";
    default sw = rw;
    default hw = r;
    default swacc=true;
    default swmod=true;    
    field {} val[1];
  } ps2_dac_runramp @0x244;
  
  reg {
    desc="PS2 DAC Ramptable Run Active";
    default sw = rw;
    default hw = w;
    field {} val[1];
  } ps2_dac_rampactive @0x248;

  reg {
    desc="PS2 DAC Current SetPt ";
    default sw = rw;
    default hw = w;
    field {} val[32];
  } ps2_dac_currsetpt @0x24C;
 


/* Gain and Offset */
reg {
    desc="PS2 DCCT 0 Offset";
    default sw = rw;
    default hw = r;
    field {} val[32];
  } ps2_dcct0_offset @0x250;

reg {
    desc="PS2 DCCT 0 Gain";
    default sw = rw;
    default hw = r;
    field {} val[32];
  } ps2_dcct0_gain @0x254;

reg {
    desc="PS2 DCCT 1 Offset";
    default sw = rw;
    default hw = r;
    field {} val[32];
  } ps2_dcct1_offset @0x258;

reg {
    desc="PS2 DCCT 1 Gain";
    default sw = rw;
    default hw = r;
    field {} val[32];
  } ps2_dcct1_gain @0x25C;


reg {
    desc="PS2 DAC Monitor Offset";
    default sw = rw;
    default hw = r;
    field {} val[32];
  } ps2_dacmon_offset @0x260;

reg {
    desc="PS2 DAC Monitor Gain";
    default sw = rw;
    default hw = r;
    field {} val[32];
  } ps2_dacmon_gain @0x264;

reg {
    desc="PS2 Voltage Monitor Offset";
    default sw = rw;
    default hw = r;
    field {} val[32];
  } ps2_volt_offset @0x268;

reg {
    desc="PS2 Voltage Monitor Gain";
    default sw = rw;
    default hw = r;
    field {} val[32];
  } ps2_volt_gain @0x26C;

reg {
    desc="PS2 GND Monitor Offset";
    default sw = rw;
    default hw = r;
    field {} val[32];
  } ps2_gnd_offset @0x270;

reg {
    desc="PS2 GND Monitor Gain";
    default sw = rw;
    default hw = r;
    field {} val[32];
  } ps2_gnd_gain @0x274;
 
reg {
    desc="PS2 Spare Monitor Offset";
    default sw = rw;
    default hw = r;
    field {} val[32];
  } ps2_spare_offset @0x278;

reg {
    desc="PS2 Spare Monitor Gain";
    default sw = rw;
    default hw = r;
    field {} val[32];
  } ps2_spare_gain @0x27C;
 
reg {
    desc="PS2 Regulator Output Offset";
    default sw = rw;
    default hw = r;
    field {} val[32];
  } ps2_reg_offset @0x280;

reg {
    desc="PS2 Regulator Output Gain";
    default sw = rw;
    default hw = r;
    field {} val[32];
  } ps2_reg_gain @0x284;
 
reg {
    desc="PS2 Error Monitor Offset";
    default sw = rw;
    default hw = r;
    field {} val[32];
  } ps2_err_offset @0x288;

reg {
    desc="PS2 Error Monitor Gain";
    default sw = rw;
    default hw = r;
    field {} val[32];
  } ps2_err_gain @0x28C;
 

reg {
    desc="PS2 DCCT1 Over Current Fault Threshold";
    default sw = rw;
    default hw = r;
    field {} val[20];
  } ps2_ovc1_thresh @0x290;
 
reg {
    desc="PS2 DCCT2 Over Current Fault Threshold";
    default sw = rw;
    default hw = r;
    field {} val[20];
  } ps2_ovc2_thresh @0x294;
 
reg {
    desc="PS2 Over Voltage Fault Threshold";
    default sw = rw;
    default hw = r;
    field {} val[16];
  } ps2_ovv_thresh @0x298;
 
reg {
    desc="PS2 PID Error1 Fault Threshold";
    default sw = rw;
    default hw = r;
    field {} val[16];
  } ps2_err1_thresh @0x29C;

reg {
    desc="PS2 PID Error2 Fault Threshold";
    default sw = rw;
    default hw = r;
    field {} val[16];
  } ps2_err2_thresh @0x2A0;

reg {
    desc="PS2 Gnd Current Fault Threshold";
    default sw = rw;
    default hw = r;
    field {} val[16];
  } ps2_ignd_thresh @0x2A4;

reg {
    desc="PS2 DCCT1 Over Current Fault Counter Limit";
    default sw = rw;
    default hw = r;
    field {} val[16];
  } ps2_ovc1_cntlim @0x2A8;
 

reg {
    desc="PS2 DCCT2 Over Current Fault Counter Limit";
    default sw = rw;
    default hw = r;
    field {} val[16];
  } ps2_ovc2_cntlim @0x2AC;
 

reg {
    desc="PS2 Over Voltage Fault Counter Limit";
    default sw = rw;
    default hw = r;
    field {} val[16];
  } ps2_ovv_cntlim @0x2B0;
 
reg {
    desc="PS2 PID Error1 Fault Counter Limit";
    default sw = rw;
    default hw = r;
    field {} val[16];
  } ps2_err1_cntlim @0x2B4;

reg {
    desc="PS2 PID Error2 Fault Counter Limit";
    default sw = rw;
    default hw = r;
    field {} val[16];
  } ps2_err2_cntlim @0x2B8;

reg {
    desc="PS2 Gnd Current Fault Counter Limit";
    default sw = rw;
    default hw = r;
    field {} val[16];
  } ps2_ignd_cntlim @0x2BC;

reg {
    desc="PS2 Digital DCCT Counter Limit";
    default sw = rw;
    default hw = r;
    field {} val[16];
  } ps2_dcct_cntlim @0x2C0;

reg {
    desc="PS2 Fault1 Counter Limit";
    default sw = rw;
    default hw = r;
    field {} val[16];
  } ps2_flt1_cntlim @0x2C4;

reg {
    desc="PS2 Fault2 Counter Limit";
    default sw = rw;
    default hw = r;
    field {} val[16];
  } ps2_flt2_cntlim @0x2C8;

reg {
    desc="PS2 Fault3 Counter Limit";
    default sw = rw;
    default hw = r;
    field {} val[16];
  } ps2_flt3_cntlim @0x2CC;

reg {
    desc="PS2 On Counter Limit";
    default sw = rw;
    default hw = r;
    field {} val[16];
  } ps2_on_cntlim @0x2D0;

reg {
    desc="PS2 Fault Clear";
    default sw = rw;
    default hw = r;
    field {} val[1];
  } ps2_fault_clear @0x2D4;

reg {
    desc="PS2 Fault Mask";
    default sw = rw;
    default hw = r;
    field {} val[16];
  } ps2_fault_mask @0x2D8;

reg {
    desc="PS2 HeartBeat Counter Limit";
    default sw = rw;
    default hw = r;
    field {} val[16];
  } ps2_heartbeat_cntlim @0x2DC;


reg {
    desc="PS2 Digital Outputs bit0=On1";
    default sw = rw;
    default hw = r; 
    field {} val[1];
  } ps2_digout_on1 @0x2E0; 
  
reg {
    desc="PS2 Digital Outputs bit1=On2";
    default sw = rw;
    default hw = r; 
    field {} val[1];
  } ps2_digout_on2 @0x2E4; 
  
reg {
    desc="PS2 Digital Outputs bit2=Reset";
    default sw = rw;
    default hw = r; 
    field {} val[1];
  } ps2_digout_reset @0x2E8; 
      
reg {
    desc="PS2 Digital Outputs bit3=spare";
    default sw = rw;
    default hw = r; 
    field {} val[1];
  } ps2_digout_spare @0x2EC; 
    
 reg {
    desc="PS2 Digital Outputs bit4=Park";
    default sw = rw;
    default hw = r; 
    field {} val[1];
  } ps2_digout_park @0x2F0; 
   
   
reg {
    desc="PS2 Digital Inputs bit0=Acon, bit1=Flt1, bit2=Flt2, bit3=spare, bit4=DCCTflt";
    default sw = rw;
    default hw = w; 
    field {} val[5];
  } ps2_digin @0x2F4; 

reg {
    desc="PS2 Active Faults (Live)";
    default sw = rw;
    default hw = w; 
    field {} val[16];
  } ps2_faults_live @0x2F8; 

reg {
    desc="PS2 Active Faults (Latched)";
    default sw = rw;
    default hw = w; 
    field {} val[16];
  } ps2_faults_lat @0x2FC; 







/**** Channel 3 *****/

/* 10Hz Data */

reg {
    desc="PS3 DCCT 0";
    default sw = rw;
    default hw = w;
    field {} val[32];
  } ps3_dcct0 @0x300;  

reg {
    desc="PS3 DCCT 1";
    default sw = rw;
    default hw = w;
    field {} val[32];
  } ps3_dcct1 @0x304;  

reg {
    desc="PS3 DAC Monitor";
    default sw = rw;
    default hw = w;
    field {} val[32];
  } ps3_dacmon @0x308;  

reg {
    desc="PS3 Voltage Monitor";
    default sw = rw;
    default hw = w;
    field {} val[32];
  } ps3_volt @0x30C;  

reg {
    desc="PS3 GND Monitor";
    default sw = rw;
    default hw = w;
    field {} val[32];
  } ps3_gnd @0x310; 

reg {
    desc="PS3 Spare Monitor";
    default sw = rw;
    default hw = w;
    field {} val[32];
  } ps3_spare @0x314; 

reg {
    desc="PS3 Regulator Output Monitor";
    default sw = rw;
    default hw = w;
    field {} val[32];
  } ps3_reg @0x318; 

reg {
    desc="PS3 Error Monitor";
    default sw = rw;
    default hw = w;
    field {} val[32];
  } ps3_err @0x31C; 


/* DAC */
reg {
    desc="PS3 DAC Offset";
    default sw = rw;
    default hw = r;
    field {} val[32];
  } ps3_dac_setpt_offset @0x320;

reg {
    desc="PS3 DAC Gain";
    default sw = rw;
    default hw = r;
    field {} val[32];
  } ps3_dac_setpt_gain @0x324;

reg {
    desc="PS3 DAC SetPoint - when in jumpmode";
    default sw = rw;
    default hw = r;
    field {} val[20];
  } ps3_dac_setpt @0x328;
  
reg {
    desc="PS3 DAC Mode 0=smooth ramp, 1=ramp table, 2=FOFB, 3=Jump Mode";
    default sw = rw;
    default hw = r;
    default swacc=true;
    default swmod=true;    
    field {} val[2];
  } ps3_dac_opmode @0x32C;  
  

reg {
    desc="PS3 DAC Control bit0=op_gnd, bit1=sdo_dis, bit2=dac_tri, bit3=rbuf, bit4=bin2sc";
    default sw = rw;
    default hw = r;   
    field {} val[8];
  } ps3_dac_cntrl @0x330;

reg {
    desc="PS3 DAC Reset";
    default sw = rw;
    default hw = r;    
    field {} val[1];
  } ps3_dac_reset @0x334;


reg {
    desc="PS3 DAC Ramp Table Length";
    default sw = rw;
    default hw = r;
    field {} val[16];
  } ps3_dac_ramplen @0x338; 


reg {
    desc="PS3 DAC Ramp Table Address";
    default sw = rw;
    default hw = r;
    field {} val[16];
  } ps3_dac_rampaddr @0x33C; 

reg {
    desc="PS3 DAC Ramp Table Data";
    default sw = rw;
    default hw = r;
    default swacc=true;
    default swmod=true;   
    field {} val[20];
  } ps3_dac_rampdata @0x340; 

reg {
    desc="PS3 DAC Run RampTable";
    default sw = rw;
    default hw = r;
    default swacc=true;
    default swmod=true;    
    field {} val[1];
  } ps3_dac_runramp @0x344;
  
  reg {
    desc="PS3 DAC Ramptable Run Active";
    default sw = rw;
    default hw = w;
    field {} val[1];
  } ps3_dac_rampactive @0x348;

 reg {
    desc="PS3 DAC Current SetPt ";
    default sw = rw;
    default hw = w;
    field {} val[32];
  } ps3_dac_currsetpt @0x34C;


/* Gain & Offset */
reg {
    desc="PS3 DCCT 0 Offset";
    default sw = rw;
    default hw = r;
    field {} val[32];
  } ps3_dcct0_offset @0x350;

reg {
    desc="PS3 DCCT 0 Gain";
    default sw = rw;
    default hw = r;
    field {} val[32];
  } ps3_dcct0_gain @0x354;

reg {
    desc="PS3 DCCT 1 Offset";
    default sw = rw;
    default hw = r;
    field {} val[32];
  } ps3_dcct1_offset @0x358;

reg {
    desc="PS3 DCCT 1 Gain";
    default sw = rw;
    default hw = r;
    field {} val[32];
  } ps3_dcct1_gain @0x35C;


reg {
    desc="PS3 DAC Monitor Offset";
    default sw = rw;
    default hw = r;
    field {} val[32];
  } ps3_dacmon_offset @0x360;

reg {
    desc="PS3 DAC Monitor Gain";
    default sw = rw;
    default hw = r;
    field {} val[32];
  } ps3_dacmon_gain @0x364;

reg {
    desc="PS3 Voltage Monitor Offset";
    default sw = rw;
    default hw = r;
    field {} val[32];
  } ps3_volt_offset @0x368;

reg {
    desc="PS3 Voltage Monitor Gain";
    default sw = rw;
    default hw = r;
    field {} val[32];
  } ps3_volt_gain @0x36C;

reg {
    desc="PS3 GND Monitor Offset";
    default sw = rw;
    default hw = r;
    field {} val[32];
  } ps3_gnd_offset @0x370;

reg {
    desc="PS3 GND Monitor Gain";
    default sw = rw;
    default hw = r;
    field {} val[32];
  } ps3_gnd_gain @0x374;
 
reg {
    desc="PS3 Spare Monitor Offset";
    default sw = rw;
    default hw = r;
    field {} val[32];
  } ps3_spare_offset @0x378;

reg {
    desc="PS3 Spare Monitor Gain";
    default sw = rw;
    default hw = r;
    field {} val[32];
  } ps3_spare_gain @0x37C;
 
reg {
    desc="PS3 Regulator Output Offset";
    default sw = rw;
    default hw = r;
    field {} val[32];
  } ps3_reg_offset @0x380;

reg {
    desc="PS3 Regulator Output Gain";
    default sw = rw;
    default hw = r;
    field {} val[32];
  } ps3_reg_gain @0x384;
 
reg {
    desc="PS3 Error Monitor Offset";
    default sw = rw;
    default hw = r;
    field {} val[32];
  } ps3_err_offset @0x388;

reg {
    desc="PS3 Error Monitor Gain";
    default sw = rw;
    default hw = r;
    field {} val[32];
  } ps3_err_gain @0x38C;
 
reg {
    desc="PS3 DCCT1 Over Current Fault Threshold";
    default sw = rw;
    default hw = r;
    field {} val[20];
  } ps3_ovc1_thresh @0x390;
 
reg {
    desc="PS3 DCCT2 Over Current Fault Threshold";
    default sw = rw;
    default hw = r;
    field {} val[20];
  } ps3_ovc2_thresh @0x394;
 
reg {
    desc="PS3 Over Voltage Fault Threshold";
    default sw = rw;
    default hw = r;
    field {} val[16];
  } ps3_ovv_thresh @0x398;
 
reg {
    desc="PS3 PID Error1 Fault Threshold";
    default sw = rw;
    default hw = r;
    field {} val[16];
  } ps3_err1_thresh @0x39C;

reg {
    desc="PS3 PID Error2 Fault Threshold";
    default sw = rw;
    default hw = r;
    field {} val[16];
  } ps3_err2_thresh @0x3A0;

reg {
    desc="PS3 Gnd Current Fault Threshold";
    default sw = rw;
    default hw = r;
    field {} val[16];
  } ps3_ignd_thresh @0x3A4;

reg {
    desc="PS3 DCCT1 Over Current Fault Counter Limit";
    default sw = rw;
    default hw = r;
    field {} val[16];
  } ps3_ovc1_cntlim @0x3A8;
 

reg {
    desc="PS3 DCCT2 Over Current Fault Counter Limit";
    default sw = rw;
    default hw = r;
    field {} val[16];
  } ps3_ovc2_cntlim @0x3AC;
 

reg {
    desc="PS3 Over Voltage Fault Counter Limit";
    default sw = rw;
    default hw = r;
    field {} val[16];
  } ps3_ovv_cntlim @0x3B0;
 
reg {
    desc="PS3 PID Error1 Fault Counter Limit";
    default sw = rw;
    default hw = r;
    field {} val[16];
  } ps3_err1_cntlim @0x3B4;

reg {
    desc="PS3 PID Error2 Fault Counter Limit";
    default sw = rw;
    default hw = r;
    field {} val[16];
  } ps3_err2_cntlim @0x3B8;

reg {
    desc="PS3 Gnd Current Fault Counter Limit";
    default sw = rw;
    default hw = r;
    field {} val[16];
  } ps3_ignd_cntlim @0x3BC;

reg {
    desc="PS3 Digital DCCT Counter Limit";
    default sw = rw;
    default hw = r;
    field {} val[16];
  } ps3_dcct_cntlim @0x3C0;

reg {
    desc="PS3 Fault1 Counter Limit";
    default sw = rw;
    default hw = r;
    field {} val[16];
  } ps3_flt1_cntlim @0x3C4;

reg {
    desc="PS3 Fault2 Counter Limit";
    default sw = rw;
    default hw = r;
    field {} val[16];
  } ps3_flt2_cntlim @0x3C8;

reg {
    desc="PS3 Fault3 Counter Limit";
    default sw = rw;
    default hw = r;
    field {} val[16];
  } ps3_flt3_cntlim @0x3CC;

reg {
    desc="PS3 On Counter Limit";
    default sw = rw;
    default hw = r;
    field {} val[16];
  } ps3_on_cntlim @0x3D0;

reg {
    desc="PS3 Fault Clear";
    default sw = rw;
    default hw = r;
    field {} val[1];
  } ps3_fault_clear @0x3D4;

reg {
    desc="PS3 Fault Mask";
    default sw = rw;
    default hw = r;
    field {} val[16];
  } ps3_fault_mask @0x3D8;

reg {
    desc="PS3 HeartBeat Counter Limit";
    default sw = rw;
    default hw = r;
    field {} val[16];
  } ps3_heartbeat_cntlim @0x3DC;


reg {
    desc="PS3 Digital Outputs bit0=On1";
    default sw = rw;
    default hw = r; 
    field {} val[1];
  } ps3_digout_on1 @0x3E0; 
  
reg {
    desc="PS3 Digital Outputs bit1=On2";
    default sw = rw;
    default hw = r; 
    field {} val[1];
  } ps3_digout_on2 @0x3E4; 
  
reg {
    desc="PS3 Digital Outputs bit2=Reset";
    default sw = rw;
    default hw = r; 
    field {} val[1];
  } ps3_digout_reset @0x3E8; 
      
reg {
    desc="PS3 Digital Outputs bit3=spare";
    default sw = rw;
    default hw = r; 
    field {} val[1];
  } ps3_digout_spare @0x3EC; 
    
 reg {
    desc="PS3 Digital Outputs bit4=Park";
    default sw = rw;
    default hw = r; 
    field {} val[1];
  } ps3_digout_park @0x3F0; 
   
   
reg {
    desc="PS3 Digital Inputs bit0=Acon, bit1=Flt1, bit2=Flt2, bit3=spare bit4=DCCTflt";
    default sw = rw;
    default hw = w; 
    field {} val[5];
  } ps3_digin @0x3F4; 


reg {
    desc="PS3 Active Faults (Live)";
    default sw = rw;
    default hw = w; 
    field {} val[16];
  } ps3_faults_live @0x3F8; 

reg {
    desc="PS3 Active Faults (Latched)";
    default sw = rw;
    default hw = w; 
    field {} val[16];
  } ps3_faults_lat @0x3FC; 







/**** Channel 4 *****/

/* 10Hz Data  */

reg {
    desc="PS4 DCCT 0";
    default sw = rw;
    default hw = w;
    field {} val[32];
  } ps4_dcct0 @0x400;  

reg {
    desc="PS3 DCCT 1";
    default sw = rw;
    default hw = w;
    field {} val[32];
  } ps4_dcct1 @0x404;  

reg {
    desc="PS4 DAC Monitor";
    default sw = rw;
    default hw = w;
    field {} val[32];
  } ps4_dacmon @0x408;  

reg {
    desc="PS4 Voltage Monitor";
    default sw = rw;
    default hw = w;
    field {} val[32];
  } ps4_volt @0x40C;  

reg {
    desc="PS4 GND Monitor";
    default sw = rw;
    default hw = w;
    field {} val[32];
  } ps4_gnd @0x410; 

reg {
    desc="PS4 Spare Monitor";
    default sw = rw;
    default hw = w;
    field {} val[32];
  } ps4_spare @0x414; 

reg {
    desc="PS4 Regulator Output";
    default sw = rw;
    default hw = w;
    field {} val[32];
  } ps4_reg @0x418; 

reg {
    desc="PS4 Error Monitor";
    default sw = rw;
    default hw = w;
    field {} val[32];
  } ps4_err @0x41C; 


/* DAC */

reg {
    desc="PS4 DAC Offset";
    default sw = rw;
    default hw = r;
    field {} val[32];
  } ps4_dac_setpt_offset @0x420;

reg {
    desc="PS4 DAC Gain";
    default sw = rw;
    default hw = r;
    field {} val[32];
  } ps4_dac_setpt_gain @0x424;

reg {
    desc="PS4 DAC SetPoint - when in jumpmode";
    default sw = rw;
    default hw = r;
    field {} val[20];
  } ps4_dac_setpt @0x428;
  
reg {
    desc="PS4 DAC Mode 0=smooth ramp, 1=ramp table, 2=FOFB, 3=Jump Mode";
    default sw = rw;
    default hw = r;
    default swacc=true;
    default swmod=true;    
    field {} val[2];
  } ps4_dac_opmode @0x42C;  
  

reg {
    desc="PS4 DAC Control bit0=op_gnd, bit1=sdo_dis, bit2=dac_tri, bit3=rbuf, bit4=bin2sc";
    default sw = rw;
    default hw = r;   
    field {} val[8];
  } ps4_dac_cntrl @0x430;

reg {
    desc="PS4 DAC Reset";
    default sw = rw;
    default hw = r;    
    field {} val[1];
  } ps4_dac_reset @0x434;


reg {
    desc="PS4 DAC Ramp Table Length";
    default sw = rw;
    default hw = r;
    field {} val[16];
  } ps4_dac_ramplen @0x438; 


reg {
    desc="PS4 DAC Ramp Table Address";
    default sw = rw;
    default hw = r;
    field {} val[16];
  } ps4_dac_rampaddr @0x43C; 

reg {
    desc="PS4 DAC Ramp Table Data";
    default sw = rw;
    default hw = r;
    default swacc=true;
    default swmod=true;   
    field {} val[20];
  } ps4_dac_rampdata @0x440; 

reg {
    desc="PS4 DAC Run RampTable";
    default sw = rw;
    default hw = r;
    default swacc=true;
    default swmod=true;    
    field {} val[1];
  } ps4_dac_runramp @0x444;
  
  reg {
    desc="PS4 DAC Ramptable Run Active";
    default sw = rw;
    default hw = w;
    field {} val[1];
  } ps4_dac_rampactive @0x448;


 reg {
    desc="PS4 DAC Current SetPt ";
    default sw = rw;
    default hw = w;
    field {} val[32];
  } ps4_dac_currsetpt @0x44C;



/* Gain & Offset */
reg {
    desc="PS4 DCCT 0 Offset";
    default sw = rw;
    default hw = r;
    field {} val[32];
  } ps4_dcct0_offset @0x450;

reg {
    desc="PS4 DCCT 0 Gain";
    default sw = rw;
    default hw = r;
    field {} val[32];
  } ps4_dcct0_gain @0x454;

reg {
    desc="PS4 DCCT 1 Offset";
    default sw = rw;
    default hw = r;
    field {} val[32];
  } ps4_dcct1_offset @0x458;

reg {
    desc="PS4 DCCT 1 Gain";
    default sw = rw;
    default hw = r;
    field {} val[32];
  } ps4_dcct1_gain @0x45C;


reg {
    desc="PS4 DAC Monitor Offset";
    default sw = rw;
    default hw = r;
    field {} val[32];
  } ps4_dacmon_offset @0x460;

reg {
    desc="PS4 DAC Monitor Gain";
    default sw = rw;
    default hw = r;
    field {} val[32];
  } ps4_dacmon_gain @0x464;

reg {
    desc="PS4 Voltage Monitor Offset";
    default sw = rw;
    default hw = r;
    field {} val[32];
  } ps4_volt_offset @0x468;

reg {
    desc="PS4 Voltage Monitor Gain";
    default sw = rw;
    default hw = r;
    field {} val[32];
  } ps4_volt_gain @0x46C;

reg {
    desc="PS4 GND Monitor Offset";
    default sw = rw;
    default hw = r;
    field {} val[32];
  } ps4_gnd_offset @0x470;

reg {
    desc="PS4 GND Monitor Gain";
    default sw = rw;
    default hw = r;
    field {} val[32];
  } ps4_gnd_gain @0x474;
 
reg {
    desc="PS4 Spare Monitor Offset";
    default sw = rw;
    default hw = r;
    field {} val[32];
  } ps4_spare_offset @0x478;

reg {
    desc="PS4 Spare Monitor Gain";
    default sw = rw;
    default hw = r;
    field {} val[32];
  } ps4_spare_gain @0x47C;
 
reg {
    desc="PS4 Regulator Output Offset";
    default sw = rw;
    default hw = r;
    field {} val[32];
  } ps4_reg_offset @0x480;

reg {
    desc="PS4 Regulator Output Gain";
    default sw = rw;
    default hw = r;
    field {} val[32];
  } ps4_reg_gain @0x484;
 
reg {
    desc="PS4 Error Monitor Offset";
    default sw = rw;
    default hw = r;
    field {} val[32];
  } ps4_err_offset @0x488;

reg {
    desc="PS4 Error Monitor Gain";
    default sw = rw;
    default hw = r;
    field {} val[32];
  } ps4_err_gain @0x48C;
 

reg {
    desc="PS4 DCCT1 Over Current Fault Threshold";
    default sw = rw;
    default hw = r;
    field {} val[20];
  } ps4_ovc1_thresh @0x490;
 
reg {
    desc="PS4 DCCT2 Over Current Fault Threshold";
    default sw = rw;
    default hw = r;
    field {} val[20];
  } ps4_ovc2_thresh @0x494;
 
reg {
    desc="PS4 Over Voltage Fault Threshold";
    default sw = rw;
    default hw = r;
    field {} val[16];
  } ps4_ovv_thresh @0x498;
 
reg {
    desc="PS4 PID Error1 Fault Threshold";
    default sw = rw;
    default hw = r;
    field {} val[16];
  } ps4_err1_thresh @0x49C;

reg {
    desc="PS4 PID Error2 Fault Threshold";
    default sw = rw;
    default hw = r;
    field {} val[16];
  } ps4_err2_thresh @0x4A0;

reg {
    desc="PS4 Gnd Current Fault Threshold";
    default sw = rw;
    default hw = r;
    field {} val[16];
  } ps4_ignd_thresh @0x4A4;

reg {
    desc="PS4 DCCT1 Over Current Fault Counter Limit";
    default sw = rw;
    default hw = r;
    field {} val[16];
  } ps4_ovc1_cntlim @0x4A8;
 

reg {
    desc="PS4 DCCT2 Over Current Fault Counter Limit";
    default sw = rw;
    default hw = r;
    field {} val[16];
  } ps4_ovc2_cntlim @0x4AC;
 

reg {
    desc="PS4 Over Voltage Fault Counter Limit";
    default sw = rw;
    default hw = r;
    field {} val[16];
  } ps4_ovv_cntlim @0x4B0;
 
reg {
    desc="PS4 PID Error1 Fault Counter Limit";
    default sw = rw;
    default hw = r;
    field {} val[16];
  } ps4_err1_cntlim @0x4B4;

reg {
    desc="PS4 PID Error2 Fault Counter Limit";
    default sw = rw;
    default hw = r;
    field {} val[16];
  } ps4_err2_cntlim @0x4B8;

reg {
    desc="PS4 Gnd Current Fault Counter Limit";
    default sw = rw;
    default hw = r;
    field {} val[16];
  } ps4_ignd_cntlim @0x4BC;

reg {
    desc="PS4 Digital DCCT Counter Limit";
    default sw = rw;
    default hw = r;
    field {} val[16];
  } ps4_dcct_cntlim @0x4C0;

reg {
    desc="PS4 Fault1 Counter Limit";
    default sw = rw;
    default hw = r;
    field {} val[16];
  } ps4_flt1_cntlim @0x4C4;

reg {
    desc="PS4 Fault2 Counter Limit";
    default sw = rw;
    default hw = r;
    field {} val[16];
  } ps4_flt2_cntlim @0x4C8;

reg {
    desc="PS4 Fault3 Counter Limit";
    default sw = rw;
    default hw = r;
    field {} val[16];
  } ps4_flt3_cntlim @0x4CC;

reg {
    desc="PS4 On Counter Limit";
    default sw = rw;
    default hw = r;
    field {} val[16];
  } ps4_on_cntlim @0x4D0;

reg {
    desc="PS4 Fault Clear";
    default sw = rw;
    default hw = r;
    field {} val[1];
  } ps4_fault_clear @0x4D4;

reg {
    desc="PS4 Fault Mask";
    default sw = rw;
    default hw = r;
    field {} val[16];
  } ps4_fault_mask @0x4D8;

reg {
    desc="PS4 HeartBeat Counter Limit";
    default sw = rw;
    default hw = r;
    field {} val[16];
  } ps4_heartbeat_cntlim @0x4DC;


reg {
    desc="PS4 Digital Outputs bit0=On1";
    default sw = rw;
    default hw = r; 
    field {} val[1];
  } ps4_digout_on1 @0x4E0; 
  
reg {
    desc="PS4 Digital Outputs bit1=On2";
    default sw = rw;
    default hw = r; 
    field {} val[1];
  } ps4_digout_on2 @0x4E4; 
  
reg {
    desc="PS4 Digital Outputs bit2=Reset";
    default sw = rw;
    default hw = r; 
    field {} val[1];
  } ps4_digout_reset @0x4E8; 
      
reg {
    desc="PS4 Digital Outputs bit3=spare";
    default sw = rw;
    default hw = r; 
    field {} val[1];
  } ps4_digout_spare @0x4EC; 
    
 reg {
    desc="PS4 Digital Outputs bit4=Park";
    default sw = rw;
    default hw = r; 
    field {} val[1];
  } ps4_digout_park @0x4F0; 
   
   
reg {
    desc="PS4 Digital Inputs bit0=Acon, bit1=Flt1, bit2=Flt2, bit3=spare, bit4=DCCTflt";
    default sw = rw;
    default hw = w; 
    field {} val[5];
  } ps4_digin @0x4F4; 

reg {
    desc="PS4 Active Faults (Live)";
    default sw = rw;
    default hw = w; 
    field {} val[16];
  } ps4_faults_live @0x4F8; 

reg {
    desc="PS4 Active Faults (Latched)";
    default sw = rw;
    default hw = w; 
    field {} val[16];
  } ps4_faults_lat @0x4FC; 









/* SnapShot Buffer Stats */

reg {
    desc="Snapshot 20 sec circular buffer current address pointer";
    default sw = rw;
    default hw = w;
    field {} val[32];
  } snapshot_addrptr @0x500;


reg {
    desc="Snapshot 20 sec circular buffer total data points written";
    default sw = rw;
    default hw = w;
    field {} val[32];
  } snapshot_totaltrigs @0x504;



reg {
    desc="Soft Trig";
    default sw = rw;
    default hw = r;  
    default swacc=true;
    default swmod=true;          
    field {} val[8];
  } softtrig @0x508; 
 
 
reg {
    desc="Test Trig - Test the 4-Fault, 4-Error, 4-Injection and EVR Trigger";
    default sw = rw;
    default hw = r;  
    default swacc=true;
    default swmod=true;          
    field {} val[16];
  } testtrig @0x50C; 
  
 
  
reg {
    desc="Soft Trig Buffer Ptr.  Buffer Point latched value gets put here on soft trigger";
    default sw = rw;
    default hw = w;
    field {} val[32];
  } softtrig_bufptr @0x520; 

reg {
    desc="Soft Trig Timestamp (s)";
    default sw = rw;
    default hw = w;
    field {} val[32];
  } softtrig_ts_s @0x524; 

reg {
    desc="Soft Trig Timestamp (ns)";
    default sw = rw;
    default hw = w;
    field {} val[32];
  } softtrig_ts_ns @0x528; 


reg {
    desc="Fault1 Buffer Ptr.  Buffer Point latched value gets put here on Fault1 trigger";
    default sw = rw;
    default hw = w;
    field {} val[32];
  } flt1trig_bufptr @0x530; 

reg {
    desc="Fault1 Trig Timestamp (s)";
    default sw = rw;
    default hw = w;
    field {} val[32];
  } flt1trig_ts_s @0x534; 

reg {
    desc="Fault1 Trig Timestamp (ns)";
    default sw = rw;
    default hw = w;
    field {} val[32];
  } flt1trig_ts_ns @0x538; 



reg {
    desc="Fault2 Buffer Ptr.  Buffer Point latched value gets put here on Fault2 trigger";
    default sw = rw;
    default hw = w;
    field {} val[32];
  } flt2trig_bufptr @0x540; 

reg {
    desc="Fault2 Trig Timestamp (s)";
    default sw = rw;
    default hw = w;
    field {} val[32];
  } flt2trig_ts_s @0x544; 

reg {
    desc="Fault2 Trig Timestamp (ns)";
    default sw = rw;
    default hw = w;
    field {} val[32];
  } flt2trig_ts_ns @0x548; 


reg {
    desc="Fault3 Buffer Ptr.  Buffer Point latched value gets put here on Fault3 trigger";
    default sw = rw;
    default hw = w;
    field {} val[32];
  } flt3trig_bufptr @0x550; 

reg {
    desc="Fault3 Trig Timestamp (s)";
    default sw = rw;
    default hw = w;
    field {} val[32];
  } flt3trig_ts_s @0x554; 

reg {
    desc="Fault3 Trig Timestamp (ns)";
    default sw = rw;
    default hw = w;
    field {} val[32];
  } flt3trig_ts_ns @0x558; 


reg {
    desc="Fault4 Buffer Ptr.  Buffer Point latched value gets put here on Fault4 trigger";
    default sw = rw;
    default hw = w;
    field {} val[32];
  } flt4trig_bufptr @0x560; 

reg {
    desc="Fault4 Trig Timestamp (s)";
    default sw = rw;
    default hw = w;
    field {} val[32];
  } flt4trig_ts_s @0x564; 

reg {
    desc="Fault4 Trig Timestamp (ns)";
    default sw = rw;
    default hw = w;
    field {} val[32];
  } flt4trig_ts_ns @0x568; 


reg {
    desc="Err1 Buffer Ptr.  Buffer Point latched value gets put here on Err1 trigger";
    default sw = rw;
    default hw = w;
    field {} val[32];
  } err1trig_bufptr @0x570; 

reg {
    desc="Err1 Trig Timestamp (s)";
    default sw = rw;
    default hw = w;
    field {} val[32];
  } err1trig_ts_s @0x574; 

reg {
    desc="Err1 Trig Timestamp (ns)";
    default sw = rw;
    default hw = w;
    field {} val[32];
  } err1trig_ts_ns @0x578; 


reg {
    desc="Err2 Buffer Ptr.  Buffer Point latched value gets put here on Err2 trigger";
    default sw = rw;
    default hw = w;
    field {} val[32];
  } err2trig_bufptr @0x580; 

reg {
    desc="Err2 Trig Timestamp (s)";
    default sw = rw;
    default hw = w;
    field {} val[32];
  } err2trig_ts_s @0x584; 

reg {
    desc="Err2 Trig Timestamp (ns)";
    default sw = rw;
    default hw = w;
    field {} val[32];
  } err2trig_ts_ns @0x588; 


reg {
    desc="Err3 Buffer Ptr.  Buffer Point latched value gets put here on Err3 trigger";
    default sw = rw;
    default hw = w;
    field {} val[32];
  } err3trig_bufptr @0x590; 

reg {
    desc="Err3 Trig Timestamp (s)";
    default sw = rw;
    default hw = w;
    field {} val[32];
  } err3trig_ts_s @0x594; 

reg {
    desc="Err3 Trig Timestamp (ns)";
    default sw = rw;
    default hw = w;
    field {} val[32];
  } err3trig_ts_ns @0x598; 


reg {
    desc="Err4 Buffer Ptr.  Buffer Point latched value gets put here on Err4 trigger";
    default sw = rw;
    default hw = w;
    field {} val[32];
  } err4trig_bufptr @0x5A0; 

reg {
    desc="Err4 Trig Timestamp (s)";
    default sw = rw;
    default hw = w;
    field {} val[32];
  } err4trig_ts_s @0x5A4; 

reg {
    desc="Err4 Trig Timestamp (ns)";
    default sw = rw;
    default hw = w;
    field {} val[32];
  } err4trig_ts_ns @0x5A8; 



reg {
    desc="Inj1 Buffer Ptr.  Buffer Point latched value gets put here on Inj1 trigger";
    default sw = rw;
    default hw = w;
    field {} val[32];
  } inj1trig_bufptr @0x5B0; 

reg {
    desc="Inj1 Trig Timestamp (s)";
    default sw = rw;
    default hw = w;
    field {} val[32];
  } inj1trig_ts_s @0x5B4; 

reg {
    desc="Inj1 Trig Timestamp (ns)";
    default sw = rw;
    default hw = w;
    field {} val[32];
  } inj1trig_ts_ns @0x5B8; 


reg {
    desc="Inj2 Buffer Ptr.  Buffer Point latched value gets put here on Inj2 trigger";
    default sw = rw;
    default hw = w;
    field {} val[32];
  } inj2trig_bufptr @0x5C0; 

reg {
    desc="Inj2 Trig Timestamp (s)";
    default sw = rw;
    default hw = w;
    field {} val[32];
  } inj2trig_ts_s @0x5C4; 

reg {
    desc="Inj2 Trig Timestamp (ns)";
    default sw = rw;
    default hw = w;
    field {} val[32];
  } inj2trig_ts_ns @0x5C8; 


reg {
    desc="Inj3 Buffer Ptr.  Buffer Point latched value gets put here on Inj3 trigger";
    default sw = rw;
    default hw = w;
    field {} val[32];
  } inj3trig_bufptr @0x5D0; 

reg {
    desc="Inj3 Trig Timestamp (s)";
    default sw = rw;
    default hw = w;
    field {} val[32];
  } inj3trig_ts_s @0x5D4; 

reg {
    desc="Inj3 Trig Timestamp (ns)";
    default sw = rw;
    default hw = w;
    field {} val[32];
  } inj3trig_ts_ns @0x5D8; 


reg {
    desc="Inj4 Buffer Ptr.  Buffer Point latched value gets put here on Inj4 trigger";
    default sw = rw;
    default hw = w;
    field {} val[32];
  } inj4trig_bufptr @0x5E0; 

reg {
    desc="Inj4 Trig Timestamp (s)";
    default sw = rw;
    default hw = w;
    field {} val[32];
  } inj4trig_ts_s @0x5E4; 

reg {
    desc="Inj4 Trig Timestamp (ns)";
    default sw = rw;
    default hw = w;
    field {} val[32];
  } inj4trig_ts_ns @0x5E8; 


reg {
    desc="EVR Buffer Ptr.  Buffer Point latched value gets put here on EVR trigger";
    default sw = rw;
    default hw = w;
    field {} val[32];
  } evrtrig_bufptr @0x5F0; 

reg {
    desc="EVR Trig Timestamp (s)";
    default sw = rw;
    default hw = w;
    field {} val[32];
  } evrtrig_ts_s @0x5F4; 

reg {
    desc="EVR Trig Timestamp (ns)";
    default sw = rw;
    default hw = w;
    field {} val[32];
  } evrtrig_ts_ns @0x5F8; 




/* DESY Version registers */

  reg {
    desc = "Module Identification Number";
    default sw = r;
    default hw = r;
    field {} data[32] = `C_ID;
  } ID @0x800;

  reg {
    desc = "Module Version Number";
    default sw = r;
    default hw = r;
    field {} changes [8] =  `C_VERSION & 0x000000FF;
    field {} patch [8]   = (`C_VERSION & 0x0000FF00) >> 8;
    field {} minor [8]   = (`C_VERSION & 0x00FF0000) >> 16;
    field {} major [8]   = (`C_VERSION & 0xFF000000) >> 24;
  } VERSION @0x804;

  reg {
    desc="Project Identification Number";
    default sw = r;
    default hw = r;
    field {} data[32] = `C_PRJ_ID;
  } PRJ_ID @0x808;

  reg {
    desc="Project Version Number";
    default sw = r;
    default hw = r;
    field {} changes [8] =  `C_PRJ_VERSION & 0x000000FF;
    field {} patch [8]   = (`C_PRJ_VERSION & 0x0000FF00) >> 8;
    field {} minor [8]   = (`C_PRJ_VERSION & 0x00FF0000) >> 16;
    field {} major [8]   = (`C_PRJ_VERSION & 0xFF000000) >> 24;
  } PRJ_VERSION @0x80C;

  reg {
    desc="Project Repository check sum.";
    default sw = r;
    default hw = r;
      field {} data[32] = `C_PRJ_SHASUM;
  } PRJ_SHASUM @0x810;

  reg {
    desc="Project compilation timestamp";
    default sw = r;
    default hw = r;
    field {} data[32] = `C_PRJ_TIMESTAMP;
  } PRJ_TIMESTAMP @0x814;







};
