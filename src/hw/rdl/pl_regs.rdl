`include "pl_regs.vh" //automatically created and added by fwk with conf variables such a C_VERSION ...

/* default values of defined variables */
`ifndef C_ID
`define C_ID 0xE1C00100
`endif
`ifndef C_VERSION
`define C_VERSION 0x00000000
`endif
`ifndef C_PRJ_ID
`define C_PRJ_ID 0xE1C00010
`endif
`ifndef C_PRJ_VERSION
`define C_PRJ_VERSION 0x00000000
`endif
`ifndef C_PRJ_TIMESTAMP
`define C_PRJ_TIMESTAMP 0x00000000
`endif
`ifndef C_PRJ_SHASUM
`define C_PRJ_SHASUM 0x00000000
`endif

/*
  module a address space
*/
addrmap pl_regs {
  name = "Example module for the example application";
  desyrdl_interface = "AXI4L";


reg {
    desc="FPGA Version";
    default sw = rw;
    default hw = w;
    field {} val[32];
  } fpgaver @0x0;  


reg {
    desc="PS Leds";
    default sw = rw;
    default hw = r;
    field {} val[8];
  } leds @0x4;
  





reg {
    desc="EVR Timestamp (s)";
    default sw = rw;
    default hw = w;
    field {} val[32];
  } evr_ts_s @0x10; 

reg {
    desc="EVR Timestamp (ns)";
    default sw = rw;
    default hw = w;
    field {} val[32];
  } evr_ts_ns @0x14; 
  
reg {
    desc="EVR Reset";
    default sw = rw;
    default hw = r;
    field {} val[8];
  } evr_reset @0x18;








/**** Channel 1 ****/

/* 10Hz Data */
reg {
    desc="PS1 DCCT 0";
    default sw = rw;
    default hw = w;
    field {} val[32];
  } ps1_dcct0 @0x100;  

reg {
    desc="PS1 DCCT 1";
    default sw = rw;
    default hw = w;
    field {} val[32];
  } ps1_dcct1 @0x104;  

reg {
    desc="PS1 DAC Setpoint Monitor";
    default sw = rw;
    default hw = w;
    field {} val[32];
  } ps1_dacsp @0x108;  

reg {
    desc="PS1 Voltage Monitor";
    default sw = rw;
    default hw = w;
    field {} val[32];
  } ps1_volt @0x10C;  

reg {
    desc="PS1 GND Monitor";
    default sw = rw;
    default hw = w;
    field {} val[32];
  } ps1_gnd @0x110; 

reg {
    desc="PS1 Spare Monitor";
    default sw = rw;
    default hw = w;
    field {} val[32];
  } ps1_spare @0x114; 

reg {
    desc="PS1 Regulator Output Monitor";
    default sw = rw;
    default hw = w;
    field {} val[32];
  } ps1_reg @0x118; 

reg {
    desc="PS1 Error";
    default sw = rw;
    default hw = w;
    field {} val[32];
  } ps1_err @0x11C; 



/* DAC */

reg {
    desc="PS1 DAC Offset";
    default sw = rw;
    default hw = r;
    field {} val[16];
  } ps1_dac_offset @0x120;

reg {
    desc="PS1 DAC Gain";
    default sw = rw;
    default hw = r;
    field {} val[16];
  } ps1_dac_gain @0x124;

reg {
    desc="PS1 DAC SetPoint - when in jumpmode";
    default sw = rw;
    default hw = r;
    field {} val[20];
  } ps1_dac_setpt @0x128;
  
reg {
    desc="PS1 DAC Mode 0=smooth ramp, 1=ramp table, 2=FOFB, 3=Jump Mode";
    default sw = rw;
    default hw = r;
    default swacc=true;
    default swmod=true;    
    field {} val[2];
  } ps1_dac_opmode @0x12C;  
  

reg {
    desc="PS1 DAC Control bit0=op_gnd, bit1=sdo_dis, bit2=dac_tri, bit3=rbuf, bit4=bin2sc";
    default sw = rw;
    default hw = r;   
    field {} val[8];
  } ps1_dac_cntrl @0x130;

reg {
    desc="PS1 DAC Reset";
    default sw = rw;
    default hw = r;    
    field {} val[1];
  } ps1_dac_reset @0x134;


reg {
    desc="PS1 DAC Ramp Table Length";
    default sw = rw;
    default hw = r;
    field {} val[16];
  } ps1_dac_ramplen @0x138; 


reg {
    desc="PS1 DAC Ramp Table Address";
    default sw = rw;
    default hw = r;
    field {} val[16];
  } ps1_dac_rampaddr @0x13C; 

reg {
    desc="PS1 DAC Ramp Table Data";
    default sw = rw;
    default hw = r;
    default swacc=true;
    default swmod=true;   
    field {} val[20];
  } ps1_dac_rampdata @0x140; 

reg {
    desc="PS1 DAC Run RampTable";
    default sw = rw;
    default hw = r;
    default swacc=true;
    default swmod=true;    
    field {} val[1];
  } ps1_dac_runramp @0x144;
  
reg {
    desc="PS1 DAC Ramptable Run Active";
    default sw = rw;
    default hw = w;
    field {} val[1];
  } ps1_dac_rampactive @0x148;

  reg {
    desc="PS1 DAC Current SetPt ";
    default sw = rw;
    default hw = w;
    field {} val[32];
  } ps1_dac_currsetpt @0x14C;


/* Gain and Offset */
reg {
    desc="PS1 DCCT 0 Offset";
    default sw = rw;
    default hw = r;
    field {} val[32];
  } ps1_dcct0_offset @0x150;

reg {
    desc="PS1 DCCT 0 Gain";
    default sw = rw;
    default hw = r;
    field {} val[32];
  } ps1_dcct0_gain @0x154;

reg {
    desc="PS1 DCCT 1 Offset";
    default sw = rw;
    default hw = r;
    field {} val[32];
  } ps1_dcct1_offset @0x158;

reg {
    desc="PS1 DCCT 1 Gain";
    default sw = rw;
    default hw = r;
    field {} val[32];
  } ps1_dcct1_gain @0x15C;


reg {
    desc="PS1 DAC Setpoint Monitor Offset";
    default sw = rw;
    default hw = r;
    field {} val[32];
  } ps1_dacsp_offset @0x160;

reg {
    desc="PS1 DAC Setpoint Monitor Gain";
    default sw = rw;
    default hw = r;
    field {} val[32];
  } ps1_dacsp_gain @0x164;

reg {
    desc="PS1 Voltage Monitor Offset";
    default sw = rw;
    default hw = r;
    field {} val[32];
  } ps1_volt_offset @0x168;

reg {
    desc="PS1 Voltage Monitor Gain";
    default sw = rw;
    default hw = r;
    field {} val[32];
  } ps1_volt_gain @0x16C;

reg {
    desc="PS1 GND Monitor Offset";
    default sw = rw;
    default hw = r;
    field {} val[32];
  } ps1_gnd_offset @0x170;

reg {
    desc="PS1 GND Monitor Gain";
    default sw = rw;
    default hw = r;
    field {} val[32];
  } ps1_gnd_gain @0x174;
 
reg {
    desc="PS1 Spare Monitor Offset";
    default sw = rw;
    default hw = r;
    field {} val[32];
  } ps1_spare_offset @0x178;

reg {
    desc="PS1 Spare Monitor Gain";
    default sw = rw;
    default hw = r;
    field {} val[32];
  } ps1_spare_gain @0x17C;
 
reg {
    desc="PS1 Regulator Output Offset";
    default sw = rw;
    default hw = r;
    field {} val[32];
  } ps1_reg_offset @0x180;

reg {
    desc="PS1 Regulator Output Gain";
    default sw = rw;
    default hw = r;
    field {} val[32];
  } ps1_reg_gain @0x184;
 
reg {
    desc="PS1 Error Monitor Offset";
    default sw = rw;
    default hw = r;
    field {} val[32];
  } ps1_err_offset @0x188;

reg {
    desc="PS1 Error Monitor Gain";
    default sw = rw;
    default hw = r;
    field {} val[32];
  } ps1_err_gain @0x18C;
 


reg {
    desc="PS1 Digital Outputs bit0=On1, bit1=On2, bit2=Reset, bit3=spare, bit4=Park";
    default sw = rw;
    default hw = r; 
    field {} val[5];
  } ps1_digout @0x190; 
  
reg {
    desc="PS1 Digital Inputs bit0=Acon, bit1=Flt1, bit2=Flt2, bit3=spare";
    default sw = rw;
    default hw = w; 
    field {} val[4];
  } ps1_digin @0x194; 






/**** Channel 2 *****/


/* PS2 10 Hz Data  */
reg {
    desc="PS2 DCCT 0";
    default sw = rw;
    default hw = w;
    field {} val[32];
  } ps2_dcct0 @0x200;  

reg {
    desc="PS2 DCCT 1";
    default sw = rw;
    default hw = w;
    field {} val[32];
  } ps2_dcct1 @0x204;  

reg {
    desc="PS2 DAC Setpoint Monitor";
    default sw = rw;
    default hw = w;
    field {} val[32];
  } ps2_dacsp @0x208;  

reg {
    desc="PS2 Voltage Monitor";
    default sw = rw;
    default hw = w;
    field {} val[32];
  } ps2_volt @0x20C;  

reg {
    desc="PS2 GND Monitor";
    default sw = rw;
    default hw = w;
    field {} val[32];
  } ps2_gnd @0x210; 

reg {
    desc="PS2 Spare Monitor";
    default sw = rw;
    default hw = w;
    field {} val[32];
  } ps2_spare @0x214; 

reg {
    desc="PS2 Regulator Output Monitor";
    default sw = rw;
    default hw = w;
    field {} val[32];
  } ps2_reg @0x218; 

reg {
    desc="PS2 Error Monitor";
    default sw = rw;
    default hw = w;
    field {} val[32];
  } ps2_err @0x21C; 


/* DAC */
reg {
    desc="PS2 DAC Offset";
    default sw = rw;
    default hw = r;
    field {} val[16];
  } ps2_dac_offset @0x220;

reg {
    desc="PS2 DAC Gain";
    default sw = rw;
    default hw = r;
    field {} val[16];
  } ps2_dac_gain @0x224;

reg {
    desc="PS2 DAC SetPoint - when in jumpmode";
    default sw = rw;
    default hw = r;
    field {} val[20];
  } ps2_dac_setpt @0x228;
  
reg {
    desc="PS2 DAC Mode 0=smooth ramp, 1=ramp table, 2=FOFB, 3=Jump Mode";
    default sw = rw;
    default hw = r;
    default swacc=true;
    default swmod=true;    
    field {} val[2];
  } ps2_dac_opmode @0x22C;  
  

reg {
    desc="PS2 DAC Control bit0=op_gnd, bit1=sdo_dis, bit2=dac_tri, bit3=rbuf, bit4=bin2sc";
    default sw = rw;
    default hw = r;   
    field {} val[8];
  } ps2_dac_cntrl @0x230;

reg {
    desc="PS2 DAC Reset";
    default sw = rw;
    default hw = r;    
    field {} val[1];
  } ps2_dac_reset @0x234;


reg {
    desc="PS2 DAC Ramp Table Length";
    default sw = rw;
    default hw = r;
    field {} val[16];
  } ps2_dac_ramplen @0x238; 


reg {
    desc="PS2 DAC Ramp Table Address";
    default sw = rw;
    default hw = r;
    field {} val[16];
  } ps2_dac_rampaddr @0x23C; 

reg {
    desc="PS2 DAC Ramp Table Data";
    default sw = rw;
    default hw = r;
    default swacc=true;
    default swmod=true;   
    field {} val[20];
  } ps2_dac_rampdata @0x240; 

reg {
    desc="PS2 DAC Run RampTable";
    default sw = rw;
    default hw = r;
    default swacc=true;
    default swmod=true;    
    field {} val[1];
  } ps2_dac_runramp @0x244;
  
  reg {
    desc="PS2 DAC Ramptable Run Active";
    default sw = rw;
    default hw = w;
    field {} val[1];
  } ps2_dac_rampactive @0x248;

  reg {
    desc="PS2 DAC Current SetPt ";
    default sw = rw;
    default hw = w;
    field {} val[32];
  } ps2_dac_currsetpt @0x24C;
 


/* Gain and Offset */
reg {
    desc="PS2 DCCT 0 Offset";
    default sw = rw;
    default hw = r;
    field {} val[32];
  } ps2_dcct0_offset @0x250;

reg {
    desc="PS2 DCCT 0 Gain";
    default sw = rw;
    default hw = r;
    field {} val[32];
  } ps2_dcct0_gain @0x254;

reg {
    desc="PS2 DCCT 1 Offset";
    default sw = rw;
    default hw = r;
    field {} val[32];
  } ps2_dcct1_offset @0x258;

reg {
    desc="PS2 DCCT 1 Gain";
    default sw = rw;
    default hw = r;
    field {} val[32];
  } ps2_dcct1_gain @0x25C;


reg {
    desc="PS2 DAC Setpoint Monitor Offset";
    default sw = rw;
    default hw = r;
    field {} val[32];
  } ps2_dacsp_offset @0x260;

reg {
    desc="PS2 DAC Setpoint Monitor Gain";
    default sw = rw;
    default hw = r;
    field {} val[32];
  } ps2_dacsp_gain @0x264;

reg {
    desc="PS2 Voltage Monitor Offset";
    default sw = rw;
    default hw = r;
    field {} val[32];
  } ps2_volt_offset @0x268;

reg {
    desc="PS2 Voltage Monitor Gain";
    default sw = rw;
    default hw = r;
    field {} val[32];
  } ps2_volt_gain @0x26C;

reg {
    desc="PS2 GND Monitor Offset";
    default sw = rw;
    default hw = r;
    field {} val[32];
  } ps2_gnd_offset @0x270;

reg {
    desc="PS2 GND Monitor Gain";
    default sw = rw;
    default hw = r;
    field {} val[32];
  } ps2_gnd_gain @0x274;
 
reg {
    desc="PS2 Spare Monitor Offset";
    default sw = rw;
    default hw = r;
    field {} val[32];
  } ps2_spare_offset @0x278;

reg {
    desc="PS2 Spare Monitor Gain";
    default sw = rw;
    default hw = r;
    field {} val[32];
  } ps2_spare_gain @0x27C;
 
reg {
    desc="PS2 Regulator Output Offset";
    default sw = rw;
    default hw = r;
    field {} val[32];
  } ps2_reg_offset @0x280;

reg {
    desc="PS2 Regulator Output Gain";
    default sw = rw;
    default hw = r;
    field {} val[32];
  } ps2_reg_gain @0x284;
 
reg {
    desc="PS2 Error Monitor Offset";
    default sw = rw;
    default hw = r;
    field {} val[32];
  } ps2_err_offset @0x288;

reg {
    desc="PS2 Error Monitor Gain";
    default sw = rw;
    default hw = r;
    field {} val[32];
  } ps2_err_gain @0x28C;
 


reg {
    desc="PS2 Digital Outputs bit0=On1, bit1=On2, bit2=Reset, bit3=spare, bit4=Park";
    default sw = rw;
    default hw = r; 
    field {} val[5];
  } ps2_digout @0x290; 
  
reg {
    desc="PS2 Digital Inputs bit0=Acon, bit1=Flt1, bit2=Flt2, bit3=spare";
    default sw = rw;
    default hw = w; 
    field {} val[4];
  } ps2_digin @0x294; 











/**** Channel 3 *****/

/* 10Hz Data */

reg {
    desc="PS3 DCCT 0";
    default sw = rw;
    default hw = w;
    field {} val[32];
  } ps3_dcct0 @0x300;  

reg {
    desc="PS3 DCCT 1";
    default sw = rw;
    default hw = w;
    field {} val[32];
  } ps3_dcct1 @0x304;  

reg {
    desc="PS3 DAC Setpoint Monitor";
    default sw = rw;
    default hw = w;
    field {} val[32];
  } ps3_dacsp @0x308;  

reg {
    desc="PS3 Voltage Monitor";
    default sw = rw;
    default hw = w;
    field {} val[32];
  } ps3_volt @0x30C;  

reg {
    desc="PS3 GND Monitor";
    default sw = rw;
    default hw = w;
    field {} val[32];
  } ps3_gnd @0x310; 

reg {
    desc="PS3 Spare Monitor";
    default sw = rw;
    default hw = w;
    field {} val[32];
  } ps3_spare @0x314; 

reg {
    desc="PS3 Regulator Output Monitor";
    default sw = rw;
    default hw = w;
    field {} val[32];
  } ps3_reg @0x318; 

reg {
    desc="PS3 Error Monitor";
    default sw = rw;
    default hw = w;
    field {} val[32];
  } ps3_err @0x31C; 


/* DAC */
reg {
    desc="PS3 DAC Offset";
    default sw = rw;
    default hw = r;
    field {} val[16];
  } ps3_dac_offset @0x320;

reg {
    desc="PS3 DAC Gain";
    default sw = rw;
    default hw = r;
    field {} val[16];
  } ps3_dac_gain @0x324;

reg {
    desc="PS3 DAC SetPoint - when in jumpmode";
    default sw = rw;
    default hw = r;
    field {} val[20];
  } ps3_dac_setpt @0x328;
  
reg {
    desc="PS3 DAC Mode 0=smooth ramp, 1=ramp table, 2=FOFB, 3=Jump Mode";
    default sw = rw;
    default hw = r;
    default swacc=true;
    default swmod=true;    
    field {} val[2];
  } ps3_dac_opmode @0x32C;  
  

reg {
    desc="PS3 DAC Control bit0=op_gnd, bit1=sdo_dis, bit2=dac_tri, bit3=rbuf, bit4=bin2sc";
    default sw = rw;
    default hw = r;   
    field {} val[8];
  } ps3_dac_cntrl @0x330;

reg {
    desc="PS3 DAC Reset";
    default sw = rw;
    default hw = r;    
    field {} val[1];
  } ps3_dac_reset @0x334;


reg {
    desc="PS3 DAC Ramp Table Length";
    default sw = rw;
    default hw = r;
    field {} val[16];
  } ps3_dac_ramplen @0x338; 


reg {
    desc="PS3 DAC Ramp Table Address";
    default sw = rw;
    default hw = r;
    field {} val[16];
  } ps3_dac_rampaddr @0x33C; 

reg {
    desc="PS3 DAC Ramp Table Data";
    default sw = rw;
    default hw = r;
    default swacc=true;
    default swmod=true;   
    field {} val[20];
  } ps3_dac_rampdata @0x340; 

reg {
    desc="PS3 DAC Run RampTable";
    default sw = rw;
    default hw = r;
    default swacc=true;
    default swmod=true;    
    field {} val[1];
  } ps3_dac_runramp @0x344;
  
  reg {
    desc="PS3 DAC Ramptable Run Active";
    default sw = rw;
    default hw = w;
    field {} val[1];
  } ps3_dac_rampactive @0x348;

 reg {
    desc="PS3 DAC Current SetPt ";
    default sw = rw;
    default hw = w;
    field {} val[32];
  } ps3_dac_currsetpt @0x34C;


/* Gain & Offset */
reg {
    desc="PS3 DCCT 0 Offset";
    default sw = rw;
    default hw = r;
    field {} val[32];
  } ps3_dcct0_offset @0x350;

reg {
    desc="PS3 DCCT 0 Gain";
    default sw = rw;
    default hw = r;
    field {} val[32];
  } ps3_dcct0_gain @0x354;

reg {
    desc="PS3 DCCT 1 Offset";
    default sw = rw;
    default hw = r;
    field {} val[32];
  } ps3_dcct1_offset @0x358;

reg {
    desc="PS3 DCCT 1 Gain";
    default sw = rw;
    default hw = r;
    field {} val[32];
  } ps3_dcct1_gain @0x35C;


reg {
    desc="PS3 DAC Setpoint Monitor Offset";
    default sw = rw;
    default hw = r;
    field {} val[32];
  } ps3_dacsp_offset @0x360;

reg {
    desc="PS3 DAC Setpoint Monitor Gain";
    default sw = rw;
    default hw = r;
    field {} val[32];
  } ps3_dacsp_gain @0x364;

reg {
    desc="PS3 Voltage Monitor Offset";
    default sw = rw;
    default hw = r;
    field {} val[32];
  } ps3_volt_offset @0x368;

reg {
    desc="PS3 Voltage Monitor Gain";
    default sw = rw;
    default hw = r;
    field {} val[32];
  } ps3_volt_gain @0x36C;

reg {
    desc="PS3 GND Monitor Offset";
    default sw = rw;
    default hw = r;
    field {} val[32];
  } ps3_gnd_offset @0x370;

reg {
    desc="PS3 GND Monitor Gain";
    default sw = rw;
    default hw = r;
    field {} val[32];
  } ps3_gnd_gain @0x374;
 
reg {
    desc="PS3 Spare Monitor Offset";
    default sw = rw;
    default hw = r;
    field {} val[32];
  } ps3_spare_offset @0x378;

reg {
    desc="PS3 Spare Monitor Gain";
    default sw = rw;
    default hw = r;
    field {} val[32];
  } ps3_spare_gain @0x37C;
 
reg {
    desc="PS3 Regulator Output Offset";
    default sw = rw;
    default hw = r;
    field {} val[32];
  } ps3_reg_offset @0x380;

reg {
    desc="PS3 Regulator Output Gain";
    default sw = rw;
    default hw = r;
    field {} val[32];
  } ps3_reg_gain @0x384;
 
reg {
    desc="PS3 Error Monitor Offset";
    default sw = rw;
    default hw = r;
    field {} val[32];
  } ps3_err_offset @0x388;

reg {
    desc="PS3 Error Monitor Gain";
    default sw = rw;
    default hw = r;
    field {} val[32];
  } ps3_err_gain @0x38C;
 
reg {
    desc="PS3 Digital Outputs bit0=On1, bit1=On2, bit2=Reset, bit3=spare, bit4=Park";
    default sw = rw;
    default hw = r; 
    field {} val[5];
  } ps3_digout @0x390; 
  
reg {
    desc="PS3 Digital Inputs bit0=Acon, bit1=Flt1, bit2=Flt2, bit3=spare";
    default sw = rw;
    default hw = w; 
    field {} val[4];
  } ps3_digin @0x394;   
  







/**** Channel 3 *****/

/* 10Hz Data  */

reg {
    desc="PS4 DCCT 0";
    default sw = rw;
    default hw = w;
    field {} val[32];
  } ps4_dcct0 @0x400;  

reg {
    desc="PS3 DCCT 1";
    default sw = rw;
    default hw = w;
    field {} val[32];
  } ps4_dcct1 @0x404;  

reg {
    desc="PS4 DAC Setpoint Monitor";
    default sw = rw;
    default hw = w;
    field {} val[32];
  } ps4_dacsp @0x408;  

reg {
    desc="PS4 Voltage Monitor";
    default sw = rw;
    default hw = w;
    field {} val[32];
  } ps4_volt @0x40C;  

reg {
    desc="PS4 GND Monitor";
    default sw = rw;
    default hw = w;
    field {} val[32];
  } ps4_gnd @0x410; 

reg {
    desc="PS4 Spare Monitor";
    default sw = rw;
    default hw = w;
    field {} val[32];
  } ps4_spare @0x414; 

reg {
    desc="PS4 Regulator Output";
    default sw = rw;
    default hw = w;
    field {} val[32];
  } ps4_reg @0x418; 

reg {
    desc="PS4 Error Monitor";
    default sw = rw;
    default hw = w;
    field {} val[32];
  } ps4_err @0x41C; 


/* DAC */

reg {
    desc="PS4 DAC Offset";
    default sw = rw;
    default hw = r;
    field {} val[16];
  } ps4_dac_offset @0x420;

reg {
    desc="PS4 DAC Gain";
    default sw = rw;
    default hw = r;
    field {} val[16];
  } ps4_dac_gain @0x424;

reg {
    desc="PS4 DAC SetPoint - when in jumpmode";
    default sw = rw;
    default hw = r;
    field {} val[20];
  } ps4_dac_setpt @0x428;
  
reg {
    desc="PS4 DAC Mode 0=smooth ramp, 1=ramp table, 2=FOFB, 3=Jump Mode";
    default sw = rw;
    default hw = r;
    default swacc=true;
    default swmod=true;    
    field {} val[2];
  } ps4_dac_opmode @0x42C;  
  

reg {
    desc="PS4 DAC Control bit0=op_gnd, bit1=sdo_dis, bit2=dac_tri, bit3=rbuf, bit4=bin2sc";
    default sw = rw;
    default hw = r;   
    field {} val[8];
  } ps4_dac_cntrl @0x430;

reg {
    desc="PS4 DAC Reset";
    default sw = rw;
    default hw = r;    
    field {} val[1];
  } ps4_dac_reset @0x434;


reg {
    desc="PS4 DAC Ramp Table Length";
    default sw = rw;
    default hw = r;
    field {} val[16];
  } ps4_dac_ramplen @0x438; 


reg {
    desc="PS4 DAC Ramp Table Address";
    default sw = rw;
    default hw = r;
    field {} val[16];
  } ps4_dac_rampaddr @0x43C; 

reg {
    desc="PS4 DAC Ramp Table Data";
    default sw = rw;
    default hw = r;
    default swacc=true;
    default swmod=true;   
    field {} val[20];
  } ps4_dac_rampdata @0x440; 

reg {
    desc="PS4 DAC Run RampTable";
    default sw = rw;
    default hw = r;
    default swacc=true;
    default swmod=true;    
    field {} val[1];
  } ps4_dac_runramp @0x444;
  
  reg {
    desc="PS4 DAC Ramptable Run Active";
    default sw = rw;
    default hw = w;
    field {} val[1];
  } ps4_dac_rampactive @0x448;


 reg {
    desc="PS4 DAC Current SetPt ";
    default sw = rw;
    default hw = w;
    field {} val[32];
  } ps4_dac_currsetpt @0x44C;



/* Gain & Offset */
reg {
    desc="PS4 DCCT 0 Offset";
    default sw = rw;
    default hw = r;
    field {} val[32];
  } ps4_dcct0_offset @0x450;

reg {
    desc="PS4 DCCT 0 Gain";
    default sw = rw;
    default hw = r;
    field {} val[32];
  } ps4_dcct0_gain @0x454;

reg {
    desc="PS4 DCCT 1 Offset";
    default sw = rw;
    default hw = r;
    field {} val[32];
  } ps4_dcct1_offset @0x458;

reg {
    desc="PS4 DCCT 1 Gain";
    default sw = rw;
    default hw = r;
    field {} val[32];
  } ps4_dcct1_gain @0x45C;


reg {
    desc="PS4 DAC Setpoint Monitor Offset";
    default sw = rw;
    default hw = r;
    field {} val[32];
  } ps4_dacsp_offset @0x460;

reg {
    desc="PS4 DAC Setpoint Monitor Gain";
    default sw = rw;
    default hw = r;
    field {} val[32];
  } ps4_dacsp_gain @0x464;

reg {
    desc="PS4 Voltage Monitor Offset";
    default sw = rw;
    default hw = r;
    field {} val[32];
  } ps4_volt_offset @0x468;

reg {
    desc="PS4 Voltage Monitor Gain";
    default sw = rw;
    default hw = r;
    field {} val[32];
  } ps4_volt_gain @0x46C;

reg {
    desc="PS4 GND Monitor Offset";
    default sw = rw;
    default hw = r;
    field {} val[32];
  } ps4_gnd_offset @0x470;

reg {
    desc="PS4 GND Monitor Gain";
    default sw = rw;
    default hw = r;
    field {} val[32];
  } ps4_gnd_gain @0x474;
 
reg {
    desc="PS4 Spare Monitor Offset";
    default sw = rw;
    default hw = r;
    field {} val[32];
  } ps4_spare_offset @0x478;

reg {
    desc="PS4 Spare Monitor Gain";
    default sw = rw;
    default hw = r;
    field {} val[32];
  } ps4_spare_gain @0x47C;
 
reg {
    desc="PS4 Regulator Output Offset";
    default sw = rw;
    default hw = r;
    field {} val[32];
  } ps4_reg_offset @0x480;

reg {
    desc="PS4 Regulator Output Gain";
    default sw = rw;
    default hw = r;
    field {} val[32];
  } ps4_reg_gain @0x484;
 
reg {
    desc="PS4 Error Monitor Offset";
    default sw = rw;
    default hw = r;
    field {} val[32];
  } ps4_err_offset @0x488;

reg {
    desc="PS4 Error Monitor Gain";
    default sw = rw;
    default hw = r;
    field {} val[32];
  } ps4_err_gain @0x48C;
 

reg {
    desc="PS4 Digital Outputs bit0=On1, bit1=On2, bit2=Reset, bit3=spare, bit4=Park";
    default sw = rw;
    default hw = r; 
    field {} val[5];
  } ps4_digout @0x490; 
  
reg {
    desc="PS4 Digital Inputs bit0=Acon, bit1=Flt1, bit2=Flt2, bit3=spare";
    default sw = rw;
    default hw = w; 
    field {} val[4];
  } ps4_digin @0x494;  






/* SnapShot Buffer Stats */

reg {
    desc="Snapshot 20 sec circular buffer current address pointer";
    default sw = rw;
    default hw = w;
    field {} val[32];
  } snapshot_addrptr @0x500;


reg {
    desc="Snapshot 20 sec circular buffer total data points written";
    default sw = rw;
    default hw = w;
    field {} val[32];
  } snapshot_totaltrigs @0x504;



reg {
    desc="Soft Trig";
    default sw = rw;
    default hw = r;  
    default swacc=true;
    default swmod=true;          
    field {} val[8];
  } softtrig @0x508; 
 
 
reg {
    desc="Test Trig - Test the 4-Fault, 4-Error and EVR Trigger";
    default sw = rw;
    default hw = r;  
    default swacc=true;
    default swmod=true;          
    field {} val[9];
  } testtrig @0x50C; 
  
 
  
reg {
    desc="Soft Trig Buffer Ptr.  Buffer Point latched value gets put here on soft trigger";
    default sw = rw;
    default hw = w;
    field {} val[32];
  } softtrig_bufptr @0x520; 

reg {
    desc="Soft Trig Timestamp (s)";
    default sw = rw;
    default hw = w;
    field {} val[32];
  } softtrig_ts_s @0x524; 

reg {
    desc="Soft Trig Timestamp (ns)";
    default sw = rw;
    default hw = w;
    field {} val[32];
  } softtrig_ts_ns @0x528; 


reg {
    desc="Fault1 Buffer Ptr.  Buffer Point latched value gets put here on Fault1 trigger";
    default sw = rw;
    default hw = w;
    field {} val[32];
  } flt1trig_bufptr @0x530; 

reg {
    desc="Fault1 Trig Timestamp (s)";
    default sw = rw;
    default hw = w;
    field {} val[32];
  } flt1trig_ts_s @0x534; 

reg {
    desc="Fault1 Trig Timestamp (ns)";
    default sw = rw;
    default hw = w;
    field {} val[32];
  } flt1trig_ts_ns @0x538; 



reg {
    desc="Fault2 Buffer Ptr.  Buffer Point latched value gets put here on Fault2 trigger";
    default sw = rw;
    default hw = w;
    field {} val[32];
  } flt2trig_bufptr @0x540; 

reg {
    desc="Fault2 Trig Timestamp (s)";
    default sw = rw;
    default hw = w;
    field {} val[32];
  } flt2trig_ts_s @0x544; 

reg {
    desc="Fault2 Trig Timestamp (ns)";
    default sw = rw;
    default hw = w;
    field {} val[32];
  } flt2trig_ts_ns @0x548; 


reg {
    desc="Fault3 Buffer Ptr.  Buffer Point latched value gets put here on Fault3 trigger";
    default sw = rw;
    default hw = w;
    field {} val[32];
  } flt3trig_bufptr @0x550; 

reg {
    desc="Fault3 Trig Timestamp (s)";
    default sw = rw;
    default hw = w;
    field {} val[32];
  } flt3trig_ts_s @0x554; 

reg {
    desc="Fault3 Trig Timestamp (ns)";
    default sw = rw;
    default hw = w;
    field {} val[32];
  } flt3trig_ts_ns @0x558; 


reg {
    desc="Fault4 Buffer Ptr.  Buffer Point latched value gets put here on Fault4 trigger";
    default sw = rw;
    default hw = w;
    field {} val[32];
  } flt4trig_bufptr @0x560; 

reg {
    desc="Fault4 Trig Timestamp (s)";
    default sw = rw;
    default hw = w;
    field {} val[32];
  } flt4trig_ts_s @0x564; 

reg {
    desc="Fault4 Trig Timestamp (ns)";
    default sw = rw;
    default hw = w;
    field {} val[32];
  } flt4trig_ts_ns @0x568; 


reg {
    desc="Err1 Buffer Ptr.  Buffer Point latched value gets put here on Err1 trigger";
    default sw = rw;
    default hw = w;
    field {} val[32];
  } err1trig_bufptr @0x570; 

reg {
    desc="Err1 Trig Timestamp (s)";
    default sw = rw;
    default hw = w;
    field {} val[32];
  } err1trig_ts_s @0x574; 

reg {
    desc="Err1 Trig Timestamp (ns)";
    default sw = rw;
    default hw = w;
    field {} val[32];
  } err1trig_ts_ns @0x578; 


reg {
    desc="Err2 Buffer Ptr.  Buffer Point latched value gets put here on Err2 trigger";
    default sw = rw;
    default hw = w;
    field {} val[32];
  } err2trig_bufptr @0x580; 

reg {
    desc="Err2 Trig Timestamp (s)";
    default sw = rw;
    default hw = w;
    field {} val[32];
  } err2trig_ts_s @0x584; 

reg {
    desc="Err2 Trig Timestamp (ns)";
    default sw = rw;
    default hw = w;
    field {} val[32];
  } err2trig_ts_ns @0x588; 


reg {
    desc="Err3 Buffer Ptr.  Buffer Point latched value gets put here on Err3 trigger";
    default sw = rw;
    default hw = w;
    field {} val[32];
  } err3trig_bufptr @0x590; 

reg {
    desc="Err3 Trig Timestamp (s)";
    default sw = rw;
    default hw = w;
    field {} val[32];
  } err3trig_ts_s @0x594; 

reg {
    desc="Err3 Trig Timestamp (ns)";
    default sw = rw;
    default hw = w;
    field {} val[32];
  } err3trig_ts_ns @0x598; 


reg {
    desc="Err4 Buffer Ptr.  Buffer Point latched value gets put here on Err4 trigger";
    default sw = rw;
    default hw = w;
    field {} val[32];
  } err4trig_bufptr @0x5A0; 

reg {
    desc="Err4 Trig Timestamp (s)";
    default sw = rw;
    default hw = w;
    field {} val[32];
  } err4trig_ts_s @0x5A4; 

reg {
    desc="Err4 Trig Timestamp (ns)";
    default sw = rw;
    default hw = w;
    field {} val[32];
  } err4trig_ts_ns @0x5A8; 



reg {
    desc="EVR Buffer Ptr.  Buffer Point latched value gets put here on EVR trigger";
    default sw = rw;
    default hw = w;
    field {} val[32];
  } evrtrig_bufptr @0x5B0; 

reg {
    desc="EVR Trig Timestamp (s)";
    default sw = rw;
    default hw = w;
    field {} val[32];
  } evrtrig_ts_s @0x5B4; 

reg {
    desc="EVR Trig Timestamp (ns)";
    default sw = rw;
    default hw = w;
    field {} val[32];
  } evrtrig_ts_ns @0x5B8; 




/* DESY Version registers */

  reg {
    desc = "Module Identification Number";
    default sw = r;
    default hw = r;
    field {} data[32] = `C_ID;
  } ID @0x800;

  reg {
    desc = "Module Version Number";
    default sw = r;
    default hw = r;
    field {} changes [8] =  `C_VERSION & 0x000000FF;
    field {} patch [8]   = (`C_VERSION & 0x0000FF00) >> 8;
    field {} minor [8]   = (`C_VERSION & 0x00FF0000) >> 16;
    field {} major [8]   = (`C_VERSION & 0xFF000000) >> 24;
  } VERSION @0x804;

  reg {
    desc="Project Identification Number";
    default sw = r;
    default hw = r;
    field {} data[32] = `C_PRJ_ID;
  } PRJ_ID @0x808;

  reg {
    desc="Project Version Number";
    default sw = r;
    default hw = r;
    field {} changes [8] =  `C_PRJ_VERSION & 0x000000FF;
    field {} patch [8]   = (`C_PRJ_VERSION & 0x0000FF00) >> 8;
    field {} minor [8]   = (`C_PRJ_VERSION & 0x00FF0000) >> 16;
    field {} major [8]   = (`C_PRJ_VERSION & 0xFF000000) >> 24;
  } PRJ_VERSION @0x80C;

  reg {
    desc="Project Repository check sum.";
    default sw = r;
    default hw = r;
      field {} data[32] = `C_PRJ_SHASUM;
  } PRJ_SHASUM @0x810;

  reg {
    desc="Project compilation timestamp";
    default sw = r;
    default hw = r;
    field {} data[32] = `C_PRJ_TIMESTAMP;
  } PRJ_TIMESTAMP @0x814;







};
